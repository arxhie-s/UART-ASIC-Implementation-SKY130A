* NGSPICE file created from uart_top.ext - technology: sky130A

* Black-box entry subcircuit for sky130_fd_sc_hd__fill_2 abstract view
.subckt sky130_fd_sc_hd__fill_2 VGND VNB VPB VPWR
.ends

* Black-box entry subcircuit for sky130_fd_sc_hd__decap_4 abstract view
.subckt sky130_fd_sc_hd__decap_4 VGND VNB VPB VPWR
.ends

* Black-box entry subcircuit for sky130_fd_sc_hd__o22a_1 abstract view
.subckt sky130_fd_sc_hd__o22a_1 A1 A2 B1 B2 VGND VNB VPB VPWR X
.ends

* Black-box entry subcircuit for sky130_fd_sc_hd__dfrtp_2 abstract view
.subckt sky130_fd_sc_hd__dfrtp_2 CLK D RESET_B VGND VNB VPB VPWR Q
.ends

* Black-box entry subcircuit for sky130_fd_sc_hd__dfrtp_1 abstract view
.subckt sky130_fd_sc_hd__dfrtp_1 CLK D RESET_B VGND VNB VPB VPWR Q
.ends

* Black-box entry subcircuit for sky130_fd_sc_hd__tapvpwrvgnd_1 abstract view
.subckt sky130_fd_sc_hd__tapvpwrvgnd_1 VGND VPWR
.ends

* Black-box entry subcircuit for sky130_fd_sc_hd__fill_1 abstract view
.subckt sky130_fd_sc_hd__fill_1 VGND VNB VPB VPWR
.ends

* Black-box entry subcircuit for sky130_fd_sc_hd__decap_3 abstract view
.subckt sky130_fd_sc_hd__decap_3 VGND VNB VPB VPWR
.ends

* Black-box entry subcircuit for sky130_fd_sc_hd__nor2_2 abstract view
.subckt sky130_fd_sc_hd__nor2_2 A B VGND VNB VPB VPWR Y
.ends

* Black-box entry subcircuit for sky130_fd_sc_hd__a22o_1 abstract view
.subckt sky130_fd_sc_hd__a22o_1 A1 A2 B1 B2 VGND VNB VPB VPWR X
.ends

* Black-box entry subcircuit for sky130_ef_sc_hd__decap_12 abstract view
.subckt sky130_ef_sc_hd__decap_12 VPWR VGND VPB VNB
.ends

* Black-box entry subcircuit for sky130_fd_sc_hd__or3_1 abstract view
.subckt sky130_fd_sc_hd__or3_1 A B C VGND VNB VPB VPWR X
.ends

* Black-box entry subcircuit for sky130_fd_sc_hd__decap_8 abstract view
.subckt sky130_fd_sc_hd__decap_8 VGND VNB VPB VPWR
.ends

* Black-box entry subcircuit for sky130_fd_sc_hd__buf_2 abstract view
.subckt sky130_fd_sc_hd__buf_2 A VGND VNB VPB VPWR X
.ends

* Black-box entry subcircuit for sky130_fd_sc_hd__dfstp_1 abstract view
.subckt sky130_fd_sc_hd__dfstp_1 CLK D SET_B VGND VNB VPB VPWR Q
.ends

* Black-box entry subcircuit for sky130_fd_sc_hd__o221a_1 abstract view
.subckt sky130_fd_sc_hd__o221a_1 A1 A2 B1 B2 C1 VGND VNB VPB VPWR X
.ends

* Black-box entry subcircuit for sky130_fd_sc_hd__decap_6 abstract view
.subckt sky130_fd_sc_hd__decap_6 VGND VNB VPB VPWR
.ends

* Black-box entry subcircuit for sky130_fd_sc_hd__or3_2 abstract view
.subckt sky130_fd_sc_hd__or3_2 A B C VGND VNB VPB VPWR X
.ends

* Black-box entry subcircuit for sky130_fd_sc_hd__nor2_1 abstract view
.subckt sky130_fd_sc_hd__nor2_1 A B VGND VNB VPB VPWR Y
.ends

* Black-box entry subcircuit for sky130_fd_sc_hd__dfrtp_4 abstract view
.subckt sky130_fd_sc_hd__dfrtp_4 CLK D RESET_B VGND VNB VPB VPWR Q
.ends

* Black-box entry subcircuit for sky130_fd_sc_hd__nand2_1 abstract view
.subckt sky130_fd_sc_hd__nand2_1 A B VGND VNB VPB VPWR Y
.ends

* Black-box entry subcircuit for sky130_fd_sc_hd__and2_1 abstract view
.subckt sky130_fd_sc_hd__and2_1 A B VGND VNB VPB VPWR X
.ends

* Black-box entry subcircuit for sky130_fd_sc_hd__a32o_1 abstract view
.subckt sky130_fd_sc_hd__a32o_1 A1 A2 A3 B1 B2 VGND VNB VPB VPWR X
.ends

* Black-box entry subcircuit for sky130_fd_sc_hd__dlygate4sd3_1 abstract view
.subckt sky130_fd_sc_hd__dlygate4sd3_1 A VGND VNB VPB VPWR X
.ends

* Black-box entry subcircuit for sky130_fd_sc_hd__mux2_1 abstract view
.subckt sky130_fd_sc_hd__mux2_1 A0 A1 S VGND VNB VPB VPWR X
.ends

* Black-box entry subcircuit for sky130_fd_sc_hd__or2_1 abstract view
.subckt sky130_fd_sc_hd__or2_1 A B VGND VNB VPB VPWR X
.ends

* Black-box entry subcircuit for sky130_fd_sc_hd__a31o_1 abstract view
.subckt sky130_fd_sc_hd__a31o_1 A1 A2 A3 B1 VGND VNB VPB VPWR X
.ends

* Black-box entry subcircuit for sky130_fd_sc_hd__o41a_1 abstract view
.subckt sky130_fd_sc_hd__o41a_1 A1 A2 A3 A4 B1 VGND VNB VPB VPWR X
.ends

* Black-box entry subcircuit for sky130_fd_sc_hd__and4_1 abstract view
.subckt sky130_fd_sc_hd__and4_1 A B C D VGND VNB VPB VPWR X
.ends

* Black-box entry subcircuit for sky130_fd_sc_hd__o2bb2a_1 abstract view
.subckt sky130_fd_sc_hd__o2bb2a_1 A1_N A2_N B1 B2 VGND VNB VPB VPWR X
.ends

* Black-box entry subcircuit for sky130_fd_sc_hd__a21bo_1 abstract view
.subckt sky130_fd_sc_hd__a21bo_1 A1 A2 B1_N VGND VNB VPB VPWR X
.ends

* Black-box entry subcircuit for sky130_fd_sc_hd__bufinv_16 abstract view
.subckt sky130_fd_sc_hd__bufinv_16 A VGND VNB VPB VPWR Y
.ends

* Black-box entry subcircuit for sky130_fd_sc_hd__mux4_1 abstract view
.subckt sky130_fd_sc_hd__mux4_1 A0 A1 A2 A3 S0 S1 VGND VNB VPB VPWR X
.ends

* Black-box entry subcircuit for sky130_fd_sc_hd__a21o_1 abstract view
.subckt sky130_fd_sc_hd__a21o_1 A1 A2 B1 VGND VNB VPB VPWR X
.ends

* Black-box entry subcircuit for sky130_fd_sc_hd__nand3_1 abstract view
.subckt sky130_fd_sc_hd__nand3_1 A B C VGND VNB VPB VPWR Y
.ends

* Black-box entry subcircuit for sky130_fd_sc_hd__inv_2 abstract view
.subckt sky130_fd_sc_hd__inv_2 A VGND VNB VPB VPWR Y
.ends

* Black-box entry subcircuit for sky130_fd_sc_hd__clkbuf_4 abstract view
.subckt sky130_fd_sc_hd__clkbuf_4 A VGND VNB VPB VPWR X
.ends

* Black-box entry subcircuit for sky130_fd_sc_hd__o21a_1 abstract view
.subckt sky130_fd_sc_hd__o21a_1 A1 A2 B1 VGND VNB VPB VPWR X
.ends

* Black-box entry subcircuit for sky130_fd_sc_hd__a41o_1 abstract view
.subckt sky130_fd_sc_hd__a41o_1 A1 A2 A3 A4 B1 VGND VNB VPB VPWR X
.ends

* Black-box entry subcircuit for sky130_fd_sc_hd__or3_4 abstract view
.subckt sky130_fd_sc_hd__or3_4 A B C VGND VNB VPB VPWR X
.ends

* Black-box entry subcircuit for sky130_fd_sc_hd__a21oi_1 abstract view
.subckt sky130_fd_sc_hd__a21oi_1 A1 A2 B1 VGND VNB VPB VPWR Y
.ends

* Black-box entry subcircuit for sky130_fd_sc_hd__a31oi_1 abstract view
.subckt sky130_fd_sc_hd__a31oi_1 A1 A2 A3 B1 VGND VNB VPB VPWR Y
.ends

* Black-box entry subcircuit for sky130_fd_sc_hd__or4bb_1 abstract view
.subckt sky130_fd_sc_hd__or4bb_1 A B C_N D_N VGND VNB VPB VPWR X
.ends

* Black-box entry subcircuit for sky130_fd_sc_hd__and3_1 abstract view
.subckt sky130_fd_sc_hd__and3_1 A B C VGND VNB VPB VPWR X
.ends

* Black-box entry subcircuit for sky130_fd_sc_hd__and2_4 abstract view
.subckt sky130_fd_sc_hd__and2_4 A B VGND VNB VPB VPWR X
.ends

* Black-box entry subcircuit for sky130_fd_sc_hd__clkbuf_16 abstract view
.subckt sky130_fd_sc_hd__clkbuf_16 A VGND VNB VPB VPWR X
.ends

* Black-box entry subcircuit for sky130_fd_sc_hd__or3b_1 abstract view
.subckt sky130_fd_sc_hd__or3b_1 A B C_N VGND VNB VPB VPWR X
.ends

* Black-box entry subcircuit for sky130_fd_sc_hd__nand3_2 abstract view
.subckt sky130_fd_sc_hd__nand3_2 A B C VGND VNB VPB VPWR Y
.ends

* Black-box entry subcircuit for sky130_fd_sc_hd__nor3_1 abstract view
.subckt sky130_fd_sc_hd__nor3_1 A B C VGND VNB VPB VPWR Y
.ends

* Black-box entry subcircuit for sky130_fd_sc_hd__o32a_1 abstract view
.subckt sky130_fd_sc_hd__o32a_1 A1 A2 A3 B1 B2 VGND VNB VPB VPWR X
.ends

* Black-box entry subcircuit for sky130_fd_sc_hd__buf_1 abstract view
.subckt sky130_fd_sc_hd__buf_1 A VGND VNB VPB VPWR X
.ends

* Black-box entry subcircuit for sky130_fd_sc_hd__o211a_1 abstract view
.subckt sky130_fd_sc_hd__o211a_1 A1 A2 B1 C1 VGND VNB VPB VPWR X
.ends

* Black-box entry subcircuit for sky130_fd_sc_hd__clkbuf_1 abstract view
.subckt sky130_fd_sc_hd__clkbuf_1 A VGND VNB VPB VPWR X
.ends

* Black-box entry subcircuit for sky130_fd_sc_hd__o21ba_1 abstract view
.subckt sky130_fd_sc_hd__o21ba_1 A1 A2 B1_N VGND VNB VPB VPWR X
.ends

* Black-box entry subcircuit for sky130_fd_sc_hd__clkbuf_2 abstract view
.subckt sky130_fd_sc_hd__clkbuf_2 A VGND VNB VPB VPWR X
.ends

* Black-box entry subcircuit for sky130_fd_sc_hd__or2_2 abstract view
.subckt sky130_fd_sc_hd__or2_2 A B VGND VNB VPB VPWR X
.ends

* Black-box entry subcircuit for sky130_fd_sc_hd__and3b_1 abstract view
.subckt sky130_fd_sc_hd__and3b_1 A_N B C VGND VNB VPB VPWR X
.ends

* Black-box entry subcircuit for sky130_fd_sc_hd__a2bb2o_1 abstract view
.subckt sky130_fd_sc_hd__a2bb2o_1 A1_N A2_N B1 B2 VGND VNB VPB VPWR X
.ends

* Black-box entry subcircuit for sky130_fd_sc_hd__and2b_1 abstract view
.subckt sky130_fd_sc_hd__and2b_1 A_N B VGND VNB VPB VPWR X
.ends

* Black-box entry subcircuit for sky130_fd_sc_hd__nor3b_2 abstract view
.subckt sky130_fd_sc_hd__nor3b_2 A B C_N VGND VNB VPB VPWR Y
.ends

* Black-box entry subcircuit for sky130_fd_sc_hd__o31a_1 abstract view
.subckt sky130_fd_sc_hd__o31a_1 A1 A2 A3 B1 VGND VNB VPB VPWR X
.ends

* Black-box entry subcircuit for sky130_fd_sc_hd__xnor2_1 abstract view
.subckt sky130_fd_sc_hd__xnor2_1 A B VGND VNB VPB VPWR Y
.ends

* Black-box entry subcircuit for sky130_fd_sc_hd__nor3_2 abstract view
.subckt sky130_fd_sc_hd__nor3_2 A B C VGND VNB VPB VPWR Y
.ends

* Black-box entry subcircuit for sky130_fd_sc_hd__o21ai_1 abstract view
.subckt sky130_fd_sc_hd__o21ai_1 A1 A2 B1 VGND VNB VPB VPWR Y
.ends

* Black-box entry subcircuit for sky130_fd_sc_hd__or4b_1 abstract view
.subckt sky130_fd_sc_hd__or4b_1 A B C D_N VGND VNB VPB VPWR X
.ends

* Black-box entry subcircuit for sky130_fd_sc_hd__a221o_1 abstract view
.subckt sky130_fd_sc_hd__a221o_1 A1 A2 B1 B2 C1 VGND VNB VPB VPWR X
.ends

* Black-box entry subcircuit for sky130_fd_sc_hd__o2111a_1 abstract view
.subckt sky130_fd_sc_hd__o2111a_1 A1 A2 B1 C1 D1 VGND VNB VPB VPWR X
.ends

* Black-box entry subcircuit for sky130_fd_sc_hd__nand3b_1 abstract view
.subckt sky130_fd_sc_hd__nand3b_1 A_N B C VGND VNB VPB VPWR Y
.ends

* Black-box entry subcircuit for sky130_fd_sc_hd__nand4_1 abstract view
.subckt sky130_fd_sc_hd__nand4_1 A B C D VGND VNB VPB VPWR Y
.ends

* Black-box entry subcircuit for sky130_fd_sc_hd__and4bb_1 abstract view
.subckt sky130_fd_sc_hd__and4bb_1 A_N B_N C D VGND VNB VPB VPWR X
.ends

.subckt uart_top VGND VPWR clk rst_n rx rx_data[0] rx_data[1] rx_data[2] rx_data[3]
+ rx_data[4] rx_data[5] rx_data[6] rx_data[7] rx_valid tx tx_busy tx_data[0] tx_data[1]
+ tx_data[2] tx_data[3] tx_data[4] tx_data[5] tx_data[6] tx_data[7] tx_start
XFILLER_22_177 VGND VGND VPWR VPWR sky130_fd_sc_hd__fill_2
XFILLER_26_85 VGND VGND VPWR VPWR sky130_fd_sc_hd__fill_2
XFILLER_13_133 VGND VGND VPWR VPWR sky130_fd_sc_hd__decap_4
X_294_ u_rx.cnt\[3\] _137_ _139_ _143_ VGND VGND VPWR VPWR _026_ sky130_fd_sc_hd__o22a_1
X_363_ clknet_2_1__leaf_clk _001_ net29 VGND VGND VPWR VPWR u_rx.state\[1\] sky130_fd_sc_hd__dfrtp_2
X_346_ clknet_2_3__leaf_clk _008_ net30 VGND VGND VPWR VPWR u_tx.cnt\[2\] sky130_fd_sc_hd__dfrtp_1
XTAP_TAPCELL_ROW_8_88 VGND VPWR sky130_fd_sc_hd__tapvpwrvgnd_1
XFILLER_10_114 VGND VGND VPWR VPWR sky130_fd_sc_hd__fill_1
XPHY_EDGE_ROW_20_Left_50 VGND VGND VPWR VPWR sky130_fd_sc_hd__decap_3
X_277_ _072_ _129_ VGND VGND VPWR VPWR _130_ sky130_fd_sc_hd__nor2_2
X_200_ u_rx.state\[3\] _061_ _063_ u_rx.state\[1\] VGND VGND VPWR VPWR _003_ sky130_fd_sc_hd__a22o_1
XFILLER_0_57 VPWR VGND VPWR VGND sky130_ef_sc_hd__decap_12
XFILLER_9_55 VGND VGND VPWR VPWR sky130_fd_sc_hd__fill_1
X_329_ _118_ _158_ _161_ VGND VGND VPWR VPWR _168_ sky130_fd_sc_hd__or3_1
XFILLER_15_6 VPWR VGND VPWR VGND sky130_ef_sc_hd__decap_12
XTAP_TAPCELL_ROW_5_78 VGND VPWR sky130_fd_sc_hd__tapvpwrvgnd_1
XFILLER_29_85 VPWR VGND VPWR VGND sky130_ef_sc_hd__decap_12
XFILLER_29_41 VPWR VGND VPWR VGND sky130_ef_sc_hd__decap_12
XFILLER_28_161 VPWR VGND VPWR VGND sky130_ef_sc_hd__decap_12
XFILLER_13_3 VPWR VGND VPWR VGND sky130_ef_sc_hd__decap_12
XFILLER_6_56 VGND VGND VPWR VPWR sky130_fd_sc_hd__decap_8
Xoutput20 net20 VGND VGND VPWR VPWR rx_valid sky130_fd_sc_hd__buf_2
X_362_ clknet_2_1__leaf_clk _000_ net30 VGND VGND VPWR VPWR u_rx.state\[0\] sky130_fd_sc_hd__dfstp_1
XFILLER_13_178 VGND VGND VPWR VPWR sky130_fd_sc_hd__fill_1
XFILLER_3_57 VGND VGND VPWR VPWR sky130_fd_sc_hd__decap_4
X_293_ u_rx.cnt\[3\] _134_ _136_ _131_ _142_ VGND VGND VPWR VPWR _143_ sky130_fd_sc_hd__o221a_1
XFILLER_8_160 VGND VGND VPWR VPWR sky130_fd_sc_hd__decap_6
XTAP_TAPCELL_ROW_12_99 VGND VPWR sky130_fd_sc_hd__tapvpwrvgnd_1
XFILLER_10_148 VGND VGND VPWR VPWR sky130_fd_sc_hd__decap_4
X_345_ clknet_2_3__leaf_clk _007_ net30 VGND VGND VPWR VPWR u_tx.cnt\[1\] sky130_fd_sc_hd__dfrtp_1
X_276_ net25 u_rx.state\[1\] u_rx.state\[3\] VGND VGND VPWR VPWR _129_ sky130_fd_sc_hd__or3_2
XFILLER_5_141 VGND VGND VPWR VPWR sky130_fd_sc_hd__decap_8
XTAP_TAPCELL_ROW_8_89 VGND VPWR sky130_fd_sc_hd__tapvpwrvgnd_1
XFILLER_23_54 VGND VGND VPWR VPWR sky130_fd_sc_hd__fill_2
XFILLER_23_21 VPWR VGND VPWR VGND sky130_ef_sc_hd__decap_12
XPHY_EDGE_ROW_21_Right_21 VGND VGND VPWR VPWR sky130_fd_sc_hd__decap_3
XPHY_EDGE_ROW_12_Right_12 VGND VGND VPWR VPWR sky130_fd_sc_hd__decap_3
X_259_ u_tx.bitidx\[3\] _113_ VGND VGND VPWR VPWR _116_ sky130_fd_sc_hd__nor2_1
XFILLER_0_69 VPWR VGND VPWR VGND sky130_ef_sc_hd__decap_12
X_328_ _159_ _161_ VGND VGND VPWR VPWR _167_ sky130_fd_sc_hd__nor2_1
XTAP_TAPCELL_ROW_5_79 VGND VPWR sky130_fd_sc_hd__tapvpwrvgnd_1
XFILLER_29_97 VGND VGND VPWR VPWR sky130_fd_sc_hd__decap_4
XFILLER_29_53 VGND VGND VPWR VPWR sky130_fd_sc_hd__decap_3
XFILLER_28_173 VGND VGND VPWR VPWR sky130_fd_sc_hd__decap_6
XFILLER_19_162 VGND VGND VPWR VPWR sky130_fd_sc_hd__decap_6
XFILLER_25_143 VGND VGND VPWR VPWR sky130_fd_sc_hd__fill_2
XFILLER_15_55 VGND VGND VPWR VPWR sky130_fd_sc_hd__fill_1
XPHY_EDGE_ROW_6_Right_6 VGND VGND VPWR VPWR sky130_fd_sc_hd__decap_3
Xoutput21 net21 VGND VGND VPWR VPWR tx sky130_fd_sc_hd__buf_2
XTAP_TAPCELL_ROW_2_69 VGND VPWR sky130_fd_sc_hd__tapvpwrvgnd_1
X_361_ clknet_2_3__leaf_clk _005_ net30 VGND VGND VPWR VPWR net22 sky130_fd_sc_hd__dfrtp_4
XTAP_TAPCELL_ROW_15_108 VGND VPWR sky130_fd_sc_hd__tapvpwrvgnd_1
X_292_ _137_ _140_ VGND VGND VPWR VPWR _142_ sky130_fd_sc_hd__nand2_1
XFILLER_9_139 VGND VGND VPWR VPWR sky130_fd_sc_hd__fill_1
X_344_ clknet_2_3__leaf_clk _006_ net30 VGND VGND VPWR VPWR u_tx.cnt\[0\] sky130_fd_sc_hd__dfrtp_2
X_275_ net25 _127_ VGND VGND VPWR VPWR _128_ sky130_fd_sc_hd__nor2_1
XFILLER_23_33 VGND VGND VPWR VPWR sky130_fd_sc_hd__decap_8
XFILLER_23_11 VGND VGND VPWR VPWR sky130_fd_sc_hd__fill_1
XFILLER_3_3 VPWR VGND VPWR VGND sky130_ef_sc_hd__decap_12
XFILLER_0_15 VPWR VGND VPWR VGND sky130_ef_sc_hd__decap_12
X_258_ _114_ _115_ VGND VGND VPWR VPWR _018_ sky130_fd_sc_hd__and2_1
X_189_ net23 u_rx.cnt\[3\] VGND VGND VPWR VPWR _065_ sky130_fd_sc_hd__nand2_1
XFILLER_9_57 VGND VGND VPWR VPWR sky130_fd_sc_hd__fill_1
X_327_ net23 _122_ _162_ _166_ net33 VGND VGND VPWR VPWR _036_ sky130_fd_sc_hd__a32o_1
XPHY_EDGE_ROW_8_Left_38 VGND VGND VPWR VPWR sky130_fd_sc_hd__decap_3
XFILLER_29_76 VGND VGND VPWR VPWR sky130_fd_sc_hd__decap_8
XFILLER_20_6 VPWR VGND VPWR VGND sky130_ef_sc_hd__decap_12
Xhold10 net19 VGND VGND VPWR VPWR net41 sky130_fd_sc_hd__dlygate4sd3_1
Xoutput22 net22 VGND VGND VPWR VPWR tx_busy sky130_fd_sc_hd__buf_2
XFILLER_25_177 VGND VGND VPWR VPWR sky130_fd_sc_hd__fill_2
XTAP_TAPCELL_ROW_18_117 VGND VPWR sky130_fd_sc_hd__tapvpwrvgnd_1
XFILLER_26_77 VGND VGND VPWR VPWR sky130_fd_sc_hd__decap_6
XTAP_TAPCELL_ROW_15_109 VGND VPWR sky130_fd_sc_hd__tapvpwrvgnd_1
X_360_ clknet_2_0__leaf_clk _022_ net29 VGND VGND VPWR VPWR u_rx.idx\[2\] sky130_fd_sc_hd__dfrtp_2
X_291_ _137_ _140_ VGND VGND VPWR VPWR _141_ sky130_fd_sc_hd__and2_1
XFILLER_3_15 VPWR VGND VPWR VGND sky130_ef_sc_hd__decap_12
XTAP_TAPCELL_ROW_20_123 VGND VPWR sky130_fd_sc_hd__tapvpwrvgnd_1
X_343_ u_tx.shreg\[8\] net10 _087_ VGND VGND VPWR VPWR _047_ sky130_fd_sc_hd__mux2_1
X_274_ u_rx.state\[1\] u_rx.state\[3\] VGND VGND VPWR VPWR _127_ sky130_fd_sc_hd__or2_1
XFILLER_5_121 VGND VGND VPWR VPWR sky130_fd_sc_hd__fill_2
XFILLER_0_27 VGND VGND VPWR VPWR sky130_fd_sc_hd__fill_1
XFILLER_29_3 VPWR VGND VPWR VGND sky130_ef_sc_hd__decap_12
XPHY_EDGE_ROW_24_Left_54 VGND VGND VPWR VPWR sky130_fd_sc_hd__decap_3
X_257_ u_tx.bitidx\[1\] u_tx.bitidx\[0\] _081_ u_tx.bitidx\[2\] VGND VGND VPWR VPWR
+ _115_ sky130_fd_sc_hd__a31o_1
XTAP_TAPCELL_ROW_9_90 VGND VPWR sky130_fd_sc_hd__tapvpwrvgnd_1
X_188_ _057_ _058_ _059_ _060_ u_rx.state\[1\] VGND VGND VPWR VPWR _064_ sky130_fd_sc_hd__o41a_1
X_326_ u_rx.idx\[2\] _162_ VGND VGND VPWR VPWR _166_ sky130_fd_sc_hd__nand2_1
X_309_ u_rx.cnt\[7\] _152_ VGND VGND VPWR VPWR _155_ sky130_fd_sc_hd__nand2_1
XFILLER_1_81 VPWR VGND VPWR VGND sky130_ef_sc_hd__decap_12
XFILLER_6_15 VPWR VGND VPWR VGND sky130_ef_sc_hd__decap_12
Xhold11 u_rx.cnt\[6\] VGND VGND VPWR VPWR net42 sky130_fd_sc_hd__dlygate4sd3_1
Xoutput12 net12 VGND VGND VPWR VPWR rx_data[0] sky130_fd_sc_hd__buf_2
XFILLER_15_79 VGND VGND VPWR VPWR sky130_fd_sc_hd__decap_3
XFILLER_15_57 VGND VGND VPWR VPWR sky130_fd_sc_hd__fill_1
XPHY_EDGE_ROW_11_Left_41 VGND VGND VPWR VPWR sky130_fd_sc_hd__decap_3
XTAP_TAPCELL_ROW_18_118 VGND VPWR sky130_fd_sc_hd__tapvpwrvgnd_1
XFILLER_11_3 VPWR VGND VPWR VGND sky130_ef_sc_hd__decap_12
XFILLER_22_126 VGND VGND VPWR VPWR sky130_fd_sc_hd__decap_3
XFILLER_7_80 VPWR VGND VPWR VGND sky130_ef_sc_hd__decap_12
XTAP_TAPCELL_ROW_23_132 VGND VPWR sky130_fd_sc_hd__tapvpwrvgnd_1
XFILLER_3_27 VPWR VGND VPWR VGND sky130_ef_sc_hd__decap_12
X_290_ u_rx.cnt\[1\] u_rx.cnt\[0\] u_rx.cnt\[2\] u_rx.cnt\[3\] VGND VGND VPWR VPWR
+ _140_ sky130_fd_sc_hd__and4_1
XTAP_TAPCELL_ROW_20_124 VGND VPWR sky130_fd_sc_hd__tapvpwrvgnd_1
X_342_ u_tx.shreg\[7\] net9 _087_ VGND VGND VPWR VPWR _046_ sky130_fd_sc_hd__mux2_1
X_273_ _120_ _126_ _125_ u_rx.idx\[2\] VGND VGND VPWR VPWR _022_ sky130_fd_sc_hd__o2bb2a_1
XFILLER_5_177 VGND VGND VPWR VPWR sky130_fd_sc_hd__fill_2
XFILLER_23_57 VGND VGND VPWR VPWR sky130_fd_sc_hd__fill_1
XFILLER_23_46 VGND VGND VPWR VPWR sky130_fd_sc_hd__decap_8
X_256_ net22 _113_ _108_ VGND VGND VPWR VPWR _114_ sky130_fd_sc_hd__a21bo_1
X_325_ net35 net23 _165_ VGND VGND VPWR VPWR _035_ sky130_fd_sc_hd__mux2_1
XTAP_TAPCELL_ROW_0_60 VGND VPWR sky130_fd_sc_hd__tapvpwrvgnd_1
XFILLER_9_15 VPWR VGND VPWR VGND sky130_ef_sc_hd__decap_12
X_187_ _057_ _061_ VGND VGND VPWR VPWR _063_ sky130_fd_sc_hd__nor2_1
XFILLER_18_24 VGND VGND VPWR VPWR sky130_fd_sc_hd__decap_4
XTAP_TAPCELL_ROW_9_91 VGND VPWR sky130_fd_sc_hd__tapvpwrvgnd_1
Xclkload0 clknet_2_0__leaf_clk VGND VGND VPWR VPWR clkload0/Y sky130_fd_sc_hd__bufinv_16
X_239_ u_tx.shreg\[5\] u_tx.shreg\[6\] u_tx.shreg\[7\] u_tx.shreg\[8\] u_tx.bitidx\[0\]
+ u_tx.bitidx\[1\] VGND VGND VPWR VPWR _100_ sky130_fd_sc_hd__mux4_1
X_308_ _137_ _152_ u_rx.cnt\[7\] VGND VGND VPWR VPWR _154_ sky130_fd_sc_hd__a21o_1
XFILLER_1_93 VPWR VGND VPWR VGND sky130_ef_sc_hd__decap_12
Xhold12 u_tx.cnt\[5\] VGND VGND VPWR VPWR net43 sky130_fd_sc_hd__dlygate4sd3_1
XFILLER_6_27 VGND VGND VPWR VPWR sky130_fd_sc_hd__fill_1
XTAP_TAPCELL_ROW_6_81 VGND VPWR sky130_fd_sc_hd__tapvpwrvgnd_1
XFILLER_25_135 VGND VGND VPWR VPWR sky130_fd_sc_hd__decap_8
XFILLER_25_102 VGND VGND VPWR VPWR sky130_fd_sc_hd__decap_4
Xoutput13 net13 VGND VGND VPWR VPWR rx_data[1] sky130_fd_sc_hd__buf_2
XPHY_EDGE_ROW_28_Right_28 VGND VGND VPWR VPWR sky130_fd_sc_hd__decap_3
XTAP_TAPCELL_ROW_26_141 VGND VPWR sky130_fd_sc_hd__tapvpwrvgnd_1
XPHY_EDGE_ROW_19_Right_19 VGND VGND VPWR VPWR sky130_fd_sc_hd__decap_3
XTAP_TAPCELL_ROW_18_119 VGND VPWR sky130_fd_sc_hd__tapvpwrvgnd_1
XFILLER_16_135 VGND VGND VPWR VPWR sky130_fd_sc_hd__decap_4
XFILLER_7_92 VGND VGND VPWR VPWR sky130_fd_sc_hd__fill_1
XTAP_TAPCELL_ROW_23_133 VGND VPWR sky130_fd_sc_hd__tapvpwrvgnd_1
XFILLER_21_160 VGND VGND VPWR VPWR sky130_fd_sc_hd__decap_8
XFILLER_3_39 VPWR VGND VPWR VGND sky130_ef_sc_hd__decap_12
XTAP_TAPCELL_ROW_20_125 VGND VPWR sky130_fd_sc_hd__tapvpwrvgnd_1
X_341_ u_tx.shreg\[6\] net8 _087_ VGND VGND VPWR VPWR _045_ sky130_fd_sc_hd__mux2_1
X_272_ u_rx.state\[1\] _057_ VGND VGND VPWR VPWR _126_ sky130_fd_sc_hd__nand2_1
XFILLER_12_15 VPWR VGND VPWR VGND sky130_ef_sc_hd__decap_12
XFILLER_5_167 VGND VGND VPWR VPWR sky130_fd_sc_hd__fill_1
X_255_ u_tx.bitidx\[1\] u_tx.bitidx\[0\] u_tx.bitidx\[2\] VGND VGND VPWR VPWR _113_
+ sky130_fd_sc_hd__nand3_1
X_186_ _061_ VGND VGND VPWR VPWR _062_ sky130_fd_sc_hd__inv_2
XFILLER_0_29 VPWR VGND VPWR VGND sky130_ef_sc_hd__decap_12
XFILLER_9_27 VPWR VGND VPWR VGND sky130_ef_sc_hd__decap_12
X_324_ _056_ _162_ VGND VGND VPWR VPWR _165_ sky130_fd_sc_hd__and2_1
XTAP_TAPCELL_ROW_0_61 VGND VPWR sky130_fd_sc_hd__tapvpwrvgnd_1
XTAP_TAPCELL_ROW_9_92 VGND VPWR sky130_fd_sc_hd__tapvpwrvgnd_1
XFILLER_1_3 VPWR VGND VPWR VGND sky130_ef_sc_hd__decap_12
Xclkload1 clknet_2_1__leaf_clk VGND VGND VPWR VPWR clkload1/X sky130_fd_sc_hd__clkbuf_4
X_238_ net38 _097_ _099_ VGND VGND VPWR VPWR _014_ sky130_fd_sc_hd__o21a_1
X_307_ _131_ _150_ _153_ _151_ net42 VGND VGND VPWR VPWR _029_ sky130_fd_sc_hd__a32o_1
XFILLER_29_57 VPWR VGND VPWR VGND sky130_ef_sc_hd__decap_12
XFILLER_20_26 VGND VGND VPWR VPWR sky130_fd_sc_hd__fill_2
Xhold13 u_rx.cnt\[4\] VGND VGND VPWR VPWR net44 sky130_fd_sc_hd__dlygate4sd3_1
XTAP_TAPCELL_ROW_29_150 VGND VPWR sky130_fd_sc_hd__tapvpwrvgnd_1
XFILLER_19_177 VGND VGND VPWR VPWR sky130_fd_sc_hd__fill_2
XTAP_TAPCELL_ROW_6_82 VGND VPWR sky130_fd_sc_hd__tapvpwrvgnd_1
XFILLER_25_169 VGND VGND VPWR VPWR sky130_fd_sc_hd__decap_8
XTAP_TAPCELL_ROW_26_142 VGND VPWR sky130_fd_sc_hd__tapvpwrvgnd_1
XFILLER_16_169 VGND VGND VPWR VPWR sky130_fd_sc_hd__decap_6
Xoutput14 net14 VGND VGND VPWR VPWR rx_data[2] sky130_fd_sc_hd__buf_2
XFILLER_26_25 VGND VGND VPWR VPWR sky130_fd_sc_hd__decap_3
XTAP_TAPCELL_ROW_23_134 VGND VPWR sky130_fd_sc_hd__tapvpwrvgnd_1
XTAP_TAPCELL_ROW_3_72 VGND VPWR sky130_fd_sc_hd__tapvpwrvgnd_1
XFILLER_8_121 VGND VGND VPWR VPWR sky130_fd_sc_hd__decap_8
XFILLER_10_109 VGND VGND VPWR VPWR sky130_fd_sc_hd__fill_2
XFILLER_12_27 VGND VGND VPWR VPWR sky130_fd_sc_hd__fill_1
X_340_ u_tx.shreg\[5\] net7 _087_ VGND VGND VPWR VPWR _044_ sky130_fd_sc_hd__mux2_1
XFILLER_5_113 VGND VGND VPWR VPWR sky130_fd_sc_hd__decap_8
X_271_ _056_ _001_ _117_ _119_ VGND VGND VPWR VPWR _125_ sky130_fd_sc_hd__and4_1
XFILLER_4_83 VGND VGND VPWR VPWR sky130_fd_sc_hd__fill_1
X_254_ _110_ _111_ _112_ _082_ u_tx.bitidx\[1\] VGND VGND VPWR VPWR _017_ sky130_fd_sc_hd__a32o_1
X_323_ net24 u_rx.idx\[1\] _051_ _162_ _164_ VGND VGND VPWR VPWR _034_ sky130_fd_sc_hd__a41o_1
XFILLER_9_39 VPWR VGND VPWR VGND sky130_ef_sc_hd__decap_12
X_185_ _058_ _059_ _060_ VGND VGND VPWR VPWR _061_ sky130_fd_sc_hd__or3_4
XTAP_TAPCELL_ROW_0_62 VGND VPWR sky130_fd_sc_hd__tapvpwrvgnd_1
Xclkload2 clknet_2_3__leaf_clk VGND VGND VPWR VPWR clkload2/X sky130_fd_sc_hd__clkbuf_4
XPHY_EDGE_ROW_28_Left_58 VGND VGND VPWR VPWR sky130_fd_sc_hd__decap_3
XFILLER_27_3 VGND VGND VPWR VPWR sky130_fd_sc_hd__fill_1
X_237_ net38 _097_ _081_ VGND VGND VPWR VPWR _099_ sky130_fd_sc_hd__a21oi_1
X_306_ _152_ VGND VGND VPWR VPWR _153_ sky130_fd_sc_hd__inv_2
XFILLER_29_69 VGND VGND VPWR VPWR sky130_fd_sc_hd__decap_4
XFILLER_1_51 VGND VGND VPWR VPWR sky130_fd_sc_hd__decap_4
XTAP_TAPCELL_ROW_29_151 VGND VPWR sky130_fd_sc_hd__tapvpwrvgnd_1
XFILLER_6_29 VPWR VGND VPWR VGND sky130_ef_sc_hd__decap_12
XTAP_TAPCELL_ROW_10_93 VGND VPWR sky130_fd_sc_hd__tapvpwrvgnd_1
XTAP_TAPCELL_ROW_6_83 VGND VPWR sky130_fd_sc_hd__tapvpwrvgnd_1
XTAP_TAPCELL_ROW_26_143 VGND VPWR sky130_fd_sc_hd__tapvpwrvgnd_1
Xoutput15 net15 VGND VGND VPWR VPWR rx_data[3] sky130_fd_sc_hd__buf_2
XPHY_EDGE_ROW_1_Right_1 VGND VGND VPWR VPWR sky130_fd_sc_hd__decap_3
XFILLER_22_118 VGND VGND VPWR VPWR sky130_fd_sc_hd__decap_8
XPHY_EDGE_ROW_15_Left_45 VGND VGND VPWR VPWR sky130_fd_sc_hd__decap_3
XTAP_TAPCELL_ROW_3_73 VGND VPWR sky130_fd_sc_hd__tapvpwrvgnd_1
XFILLER_8_166 VGND VGND VPWR VPWR sky130_fd_sc_hd__fill_1
X_270_ u_rx.idx\[1\] _124_ _120_ VGND VGND VPWR VPWR _021_ sky130_fd_sc_hd__mux2_1
X_322_ u_rx.idx\[1\] _051_ _162_ _055_ VGND VGND VPWR VPWR _164_ sky130_fd_sc_hd__a31oi_1
X_253_ u_tx.bitidx\[1\] u_tx.bitidx\[0\] VGND VGND VPWR VPWR _112_ sky130_fd_sc_hd__or2_1
XFILLER_13_93 VGND VGND VPWR VPWR sky130_fd_sc_hd__decap_4
XTAP_TAPCELL_ROW_0_63 VGND VPWR sky130_fd_sc_hd__tapvpwrvgnd_1
X_184_ u_rx.cnt\[1\] u_rx.cnt\[2\] u_rx.cnt\[0\] u_rx.cnt\[8\] VGND VGND VPWR VPWR
+ _060_ sky130_fd_sc_hd__or4bb_1
XFILLER_24_70 VGND VGND VPWR VPWR sky130_fd_sc_hd__decap_4
X_236_ _082_ _096_ _098_ VGND VGND VPWR VPWR _013_ sky130_fd_sc_hd__and3_1
XPHY_EDGE_ROW_3_Left_33 VGND VGND VPWR VPWR sky130_fd_sc_hd__decap_3
X_305_ u_rx.cnt\[5\] u_rx.cnt\[4\] u_rx.cnt\[6\] _140_ VGND VGND VPWR VPWR _152_ sky130_fd_sc_hd__and4_1
XFILLER_29_15 VPWR VGND VPWR VGND sky130_ef_sc_hd__decap_12
XFILLER_19_113 VGND VGND VPWR VPWR sky130_fd_sc_hd__decap_3
XFILLER_10_83 VGND VGND VPWR VPWR sky130_fd_sc_hd__fill_1
XTAP_TAPCELL_ROW_10_94 VGND VPWR sky130_fd_sc_hd__tapvpwrvgnd_1
XTAP_TAPCELL_ROW_29_152 VGND VPWR sky130_fd_sc_hd__tapvpwrvgnd_1
X_219_ _052_ net11 VGND VGND VPWR VPWR _087_ sky130_fd_sc_hd__and2_4
XFILLER_19_81 VGND VGND VPWR VPWR sky130_fd_sc_hd__decap_8
Xoutput16 net16 VGND VGND VPWR VPWR rx_data[4] sky130_fd_sc_hd__buf_2
XFILLER_24_171 VGND VGND VPWR VPWR sky130_fd_sc_hd__decap_8
Xclkbuf_0_clk clk VGND VGND VPWR VPWR clknet_0_clk sky130_fd_sc_hd__clkbuf_16
XPHY_EDGE_ROW_24_Right_24 VGND VGND VPWR VPWR sky130_fd_sc_hd__decap_3
XPHY_EDGE_ROW_15_Right_15 VGND VGND VPWR VPWR sky130_fd_sc_hd__decap_3
XFILLER_13_108 VGND VGND VPWR VPWR sky130_fd_sc_hd__decap_4
XTAP_TAPCELL_ROW_3_74 VGND VPWR sky130_fd_sc_hd__tapvpwrvgnd_1
XFILLER_12_141 VGND VGND VPWR VPWR sky130_fd_sc_hd__fill_2
XFILLER_12_29 VGND VGND VPWR VPWR sky130_fd_sc_hd__fill_2
XFILLER_4_41 VPWR VGND VPWR VGND sky130_ef_sc_hd__decap_12
XFILLER_4_85 VGND VGND VPWR VPWR sky130_fd_sc_hd__fill_1
X_252_ u_tx.bitidx\[1\] u_tx.bitidx\[0\] VGND VGND VPWR VPWR _111_ sky130_fd_sc_hd__nand2_1
XTAP_TAPCELL_ROW_0_64 VGND VPWR sky130_fd_sc_hd__tapvpwrvgnd_1
X_321_ net34 net23 _163_ VGND VGND VPWR VPWR _033_ sky130_fd_sc_hd__mux2_1
X_183_ u_rx.cnt\[5\] u_rx.cnt\[4\] VGND VGND VPWR VPWR _059_ sky130_fd_sc_hd__nand2_1
XFILLER_24_93 VGND VGND VPWR VPWR sky130_fd_sc_hd__fill_2
X_235_ _097_ VGND VGND VPWR VPWR _098_ sky130_fd_sc_hd__inv_2
X_304_ net23 _069_ _130_ VGND VGND VPWR VPWR _151_ sky130_fd_sc_hd__a21o_1
XFILLER_20_18 VGND VGND VPWR VPWR sky130_fd_sc_hd__decap_8
XFILLER_29_27 VGND VGND VPWR VPWR sky130_fd_sc_hd__fill_1
XTAP_TAPCELL_ROW_10_95 VGND VPWR sky130_fd_sc_hd__tapvpwrvgnd_1
XTAP_TAPCELL_ROW_29_153 VGND VPWR sky130_fd_sc_hd__tapvpwrvgnd_1
X_218_ u_tx.cnt\[2\] _085_ VGND VGND VPWR VPWR _086_ sky130_fd_sc_hd__and2_1
XFILLER_19_169 VGND VGND VPWR VPWR sky130_fd_sc_hd__decap_8
XFILLER_25_106 VGND VGND VPWR VPWR sky130_fd_sc_hd__fill_1
XFILLER_15_18 VPWR VGND VPWR VGND sky130_ef_sc_hd__decap_12
Xoutput17 net17 VGND VGND VPWR VPWR rx_data[5] sky130_fd_sc_hd__buf_2
XFILLER_16_139 VGND VGND VPWR VPWR sky130_fd_sc_hd__fill_1
XFILLER_26_17 VGND VGND VPWR VPWR sky130_fd_sc_hd__decap_8
Xclkbuf_2_0__f_clk clknet_0_clk VGND VGND VPWR VPWR clknet_2_0__leaf_clk sky130_fd_sc_hd__clkbuf_16
XFILLER_4_53 VPWR VGND VPWR VGND sky130_ef_sc_hd__decap_12
X_251_ _110_ _109_ u_tx.bitidx\[0\] VGND VGND VPWR VPWR _016_ sky130_fd_sc_hd__mux2_1
Xfanout30 net31 VGND VGND VPWR VPWR net30 sky130_fd_sc_hd__clkbuf_4
XFILLER_13_62 VGND VGND VPWR VPWR sky130_fd_sc_hd__decap_4
XFILLER_13_51 VGND VGND VPWR VPWR sky130_fd_sc_hd__decap_4
XTAP_TAPCELL_ROW_0_65 VGND VPWR sky130_fd_sc_hd__tapvpwrvgnd_1
X_320_ _050_ u_rx.idx\[0\] _162_ VGND VGND VPWR VPWR _163_ sky130_fd_sc_hd__and3_1
X_182_ u_rx.cnt\[3\] u_rx.cnt\[6\] u_rx.cnt\[7\] VGND VGND VPWR VPWR _058_ sky130_fd_sc_hd__or3b_1
XFILLER_18_29 VGND VGND VPWR VPWR sky130_fd_sc_hd__fill_2
X_234_ u_tx.cnt\[5\] u_tx.cnt\[6\] u_tx.cnt\[7\] _090_ VGND VGND VPWR VPWR _097_ sky130_fd_sc_hd__and4_1
X_303_ u_rx.cnt\[5\] u_rx.cnt\[4\] _141_ u_rx.cnt\[6\] VGND VGND VPWR VPWR _150_ sky130_fd_sc_hd__a31o_1
XTAP_TAPCELL_ROW_29_154 VGND VPWR sky130_fd_sc_hd__tapvpwrvgnd_1
X_217_ net22 u_tx.cnt\[1\] u_tx.cnt\[0\] VGND VGND VPWR VPWR _085_ sky130_fd_sc_hd__and3_1
XFILLER_25_129 VGND VGND VPWR VPWR sky130_fd_sc_hd__fill_1
XFILLER_25_3 VPWR VGND VPWR VGND sky130_ef_sc_hd__decap_12
Xoutput18 net18 VGND VGND VPWR VPWR rx_data[6] sky130_fd_sc_hd__buf_2
XFILLER_26_29 VGND VGND VPWR VPWR sky130_fd_sc_hd__fill_1
XPHY_EDGE_ROW_5_Right_5 VGND VGND VPWR VPWR sky130_fd_sc_hd__decap_3
XPHY_EDGE_ROW_19_Left_49 VGND VGND VPWR VPWR sky130_fd_sc_hd__decap_3
XTAP_TAPCELL_ROW_14_105 VGND VPWR sky130_fd_sc_hd__tapvpwrvgnd_1
XFILLER_12_121 VGND VGND VPWR VPWR sky130_fd_sc_hd__decap_8
XFILLER_12_154 VGND VGND VPWR VPWR sky130_fd_sc_hd__decap_4
XFILLER_27_61 VGND VGND VPWR VPWR sky130_fd_sc_hd__fill_1
XFILLER_2_109 VGND VGND VPWR VPWR sky130_fd_sc_hd__decap_8
XFILLER_4_65 VPWR VGND VPWR VGND sky130_ef_sc_hd__decap_12
X_250_ net22 _108_ VGND VGND VPWR VPWR _110_ sky130_fd_sc_hd__and2_1
Xfanout31 net1 VGND VGND VPWR VPWR net31 sky130_fd_sc_hd__clkbuf_4
X_181_ u_rx.idx\[2\] u_rx.idx\[1\] u_rx.idx\[0\] VGND VGND VPWR VPWR _057_ sky130_fd_sc_hd__nand3_2
X_379_ clknet_2_1__leaf_clk _034_ net29 VGND VGND VPWR VPWR net14 sky130_fd_sc_hd__dfrtp_1
XFILLER_1_164 VGND VGND VPWR VPWR sky130_fd_sc_hd__fill_1
X_233_ u_tx.cnt\[5\] u_tx.cnt\[6\] _090_ u_tx.cnt\[7\] VGND VGND VPWR VPWR _096_ sky130_fd_sc_hd__a31o_1
X_302_ u_rx.cnt\[5\] _148_ _149_ VGND VGND VPWR VPWR _028_ sky130_fd_sc_hd__a21bo_1
XFILLER_1_55 VGND VGND VPWR VPWR sky130_fd_sc_hd__fill_1
XFILLER_29_29 VPWR VGND VPWR VGND sky130_ef_sc_hd__decap_12
XFILLER_28_138 VGND VGND VPWR VPWR sky130_fd_sc_hd__fill_2
XTAP_TAPCELL_ROW_29_155 VGND VPWR sky130_fd_sc_hd__tapvpwrvgnd_1
XPHY_EDGE_ROW_7_Left_37 VGND VGND VPWR VPWR sky130_fd_sc_hd__decap_3
XFILLER_10_97 VPWR VGND VPWR VGND sky130_ef_sc_hd__decap_12
X_216_ _081_ _083_ _084_ VGND VGND VPWR VPWR _007_ sky130_fd_sc_hd__nor3_1
XFILLER_24_141 VGND VGND VPWR VPWR sky130_fd_sc_hd__decap_8
XFILLER_16_108 VGND VGND VPWR VPWR sky130_fd_sc_hd__fill_1
Xoutput19 net19 VGND VGND VPWR VPWR rx_data[7] sky130_fd_sc_hd__buf_2
XTAP_TAPCELL_ROW_17_114 VGND VPWR sky130_fd_sc_hd__tapvpwrvgnd_1
XFILLER_15_141 VGND VGND VPWR VPWR sky130_fd_sc_hd__decap_6
XFILLER_7_65 VPWR VGND VPWR VGND sky130_ef_sc_hd__decap_12
XFILLER_21_177 VGND VGND VPWR VPWR sky130_fd_sc_hd__fill_2
XPHY_EDGE_ROW_20_Right_20 VGND VGND VPWR VPWR sky130_fd_sc_hd__decap_3
XFILLER_16_96 VGND VGND VPWR VPWR sky130_fd_sc_hd__decap_4
XFILLER_16_41 VPWR VGND VPWR VGND sky130_ef_sc_hd__decap_12
XTAP_TAPCELL_ROW_14_106 VGND VPWR sky130_fd_sc_hd__tapvpwrvgnd_1
XFILLER_8_148 VPWR VGND VPWR VGND sky130_ef_sc_hd__decap_12
XPHY_EDGE_ROW_11_Right_11 VGND VGND VPWR VPWR sky130_fd_sc_hd__decap_3
XFILLER_12_111 VGND VGND VPWR VPWR sky130_fd_sc_hd__decap_4
XFILLER_4_77 VGND VGND VPWR VPWR sky130_fd_sc_hd__decap_6
X_180_ _050_ _051_ VGND VGND VPWR VPWR _056_ sky130_fd_sc_hd__nor2_1
X_378_ clknet_2_1__leaf_clk _033_ net29 VGND VGND VPWR VPWR net13 sky130_fd_sc_hd__dfrtp_1
XFILLER_24_85 VGND VGND VPWR VPWR sky130_fd_sc_hd__decap_8
XFILLER_24_74 VGND VGND VPWR VPWR sky130_fd_sc_hd__fill_1
X_232_ _095_ _054_ _094_ VGND VGND VPWR VPWR _012_ sky130_fd_sc_hd__mux2_1
X_301_ u_rx.cnt\[5\] _128_ _147_ _061_ _048_ VGND VGND VPWR VPWR _149_ sky130_fd_sc_hd__o32a_1
XPHY_EDGE_ROW_23_Left_53 VGND VGND VPWR VPWR sky130_fd_sc_hd__decap_3
XFILLER_19_139 VGND VGND VPWR VPWR sky130_fd_sc_hd__decap_3
X_215_ u_tx.cnt\[0\] _073_ u_tx.cnt\[1\] VGND VGND VPWR VPWR _084_ sky130_fd_sc_hd__a21oi_1
XTAP_TAPCELL_ROW_17_115 VGND VPWR sky130_fd_sc_hd__tapvpwrvgnd_1
XPHY_EDGE_ROW_10_Left_40 VGND VGND VPWR VPWR sky130_fd_sc_hd__decap_3
XFILLER_16_53 VGND VGND VPWR VPWR sky130_fd_sc_hd__decap_4
XTAP_TAPCELL_ROW_14_107 VGND VPWR sky130_fd_sc_hd__tapvpwrvgnd_1
XFILLER_12_134 VGND VGND VPWR VPWR sky130_fd_sc_hd__decap_6
XFILLER_5_108 VGND VGND VPWR VPWR sky130_fd_sc_hd__decap_4
XFILLER_4_141 VGND VGND VPWR VPWR sky130_fd_sc_hd__decap_4
X_377_ clknet_2_1__leaf_clk _032_ net31 VGND VGND VPWR VPWR net12 sky130_fd_sc_hd__dfrtp_1
XFILLER_1_177 VGND VGND VPWR VPWR sky130_fd_sc_hd__fill_2
XFILLER_1_133 VGND VGND VPWR VPWR sky130_fd_sc_hd__decap_3
XFILLER_1_111 VGND VGND VPWR VPWR sky130_fd_sc_hd__fill_1
XFILLER_8_3 VPWR VGND VPWR VGND sky130_ef_sc_hd__decap_12
X_231_ _054_ _087_ VGND VGND VPWR VPWR _095_ sky130_fd_sc_hd__nor2_1
X_300_ _061_ _129_ _147_ _130_ VGND VGND VPWR VPWR _148_ sky130_fd_sc_hd__a31o_1
XFILLER_1_57 VPWR VGND VPWR VGND sky130_ef_sc_hd__decap_12
Xinput1 rst_n VGND VGND VPWR VPWR net1 sky130_fd_sc_hd__buf_1
X_214_ net22 net11 u_tx.cnt\[0\] u_tx.cnt\[1\] VGND VGND VPWR VPWR _083_ sky130_fd_sc_hd__o211a_1
XTAP_TAPCELL_ROW_17_116 VGND VPWR sky130_fd_sc_hd__tapvpwrvgnd_1
XFILLER_23_3 VGND VGND VPWR VPWR sky130_fd_sc_hd__decap_8
XFILLER_21_135 VGND VGND VPWR VPWR sky130_fd_sc_hd__fill_1
XTAP_TAPCELL_ROW_22_130 VGND VPWR sky130_fd_sc_hd__tapvpwrvgnd_1
XFILLER_16_65 VGND VGND VPWR VPWR sky130_fd_sc_hd__fill_1
XFILLER_8_139 VGND VGND VPWR VPWR sky130_fd_sc_hd__fill_1
XPHY_EDGE_ROW_9_Right_9 VGND VGND VPWR VPWR sky130_fd_sc_hd__decap_3
XFILLER_27_53 VGND VGND VPWR VPWR sky130_fd_sc_hd__decap_3
X_393_ clknet_2_2__leaf_clk _047_ net26 VGND VGND VPWR VPWR u_tx.shreg\[8\] sky130_fd_sc_hd__dfstp_1
Xfanout23 u_rx.rx_s2 VGND VGND VPWR VPWR net23 sky130_fd_sc_hd__buf_2
XFILLER_13_66 VGND VGND VPWR VPWR sky130_fd_sc_hd__fill_1
XFILLER_13_55 VGND VGND VPWR VPWR sky130_fd_sc_hd__fill_1
X_376_ clknet_2_0__leaf_clk net32 net28 VGND VGND VPWR VPWR u_rx.rx_s2 sky130_fd_sc_hd__dfstp_1
XFILLER_24_65 VGND VGND VPWR VPWR sky130_fd_sc_hd__fill_1
X_230_ u_tx.cnt\[5\] _085_ _089_ VGND VGND VPWR VPWR _094_ sky130_fd_sc_hd__and3_1
X_359_ clknet_2_1__leaf_clk _021_ net29 VGND VGND VPWR VPWR u_rx.idx\[1\] sky130_fd_sc_hd__dfrtp_4
XFILLER_1_69 VPWR VGND VPWR VGND sky130_ef_sc_hd__decap_12
Xinput2 rx VGND VGND VPWR VPWR net2 sky130_fd_sc_hd__clkbuf_1
X_213_ _073_ _080_ VGND VGND VPWR VPWR _082_ sky130_fd_sc_hd__nand2_1
XFILLER_18_141 VPWR VGND VPWR VGND sky130_ef_sc_hd__decap_12
XFILLER_24_100 VPWR VGND VPWR VGND sky130_ef_sc_hd__decap_12
XFILLER_21_44 VPWR VGND VPWR VGND sky130_ef_sc_hd__decap_12
XFILLER_21_22 VGND VGND VPWR VPWR sky130_fd_sc_hd__fill_1
XFILLER_15_111 VGND VGND VPWR VPWR sky130_fd_sc_hd__fill_1
XTAP_TAPCELL_ROW_22_131 VGND VPWR sky130_fd_sc_hd__tapvpwrvgnd_1
XFILLER_21_169 VGND VGND VPWR VPWR sky130_fd_sc_hd__decap_8
XFILLER_12_158 VGND VGND VPWR VPWR sky130_fd_sc_hd__fill_1
XFILLER_8_129 VGND VGND VPWR VPWR sky130_fd_sc_hd__fill_2
XFILLER_27_76 VGND VGND VPWR VPWR sky130_fd_sc_hd__fill_2
XFILLER_27_43 VGND VGND VPWR VPWR sky130_fd_sc_hd__fill_1
X_392_ clknet_2_2__leaf_clk _046_ net26 VGND VGND VPWR VPWR u_tx.shreg\[7\] sky130_fd_sc_hd__dfstp_1
Xfanout24 u_rx.rx_s2 VGND VGND VPWR VPWR net24 sky130_fd_sc_hd__buf_1
XFILLER_1_113 VPWR VGND VPWR VGND sky130_ef_sc_hd__decap_12
X_375_ clknet_2_3__leaf_clk _031_ net27 VGND VGND VPWR VPWR u_rx.cnt\[8\] sky130_fd_sc_hd__dfrtp_1
XFILLER_1_15 VPWR VGND VPWR VGND sky130_ef_sc_hd__decap_12
X_358_ clknet_2_1__leaf_clk _020_ net29 VGND VGND VPWR VPWR u_rx.idx\[0\] sky130_fd_sc_hd__dfrtp_4
XPHY_EDGE_ROW_27_Right_27 VGND VGND VPWR VPWR sky130_fd_sc_hd__decap_3
Xinput3 tx_data[0] VGND VGND VPWR VPWR net3 sky130_fd_sc_hd__clkbuf_1
XPHY_EDGE_ROW_18_Right_18 VGND VGND VPWR VPWR sky130_fd_sc_hd__decap_3
X_289_ _069_ _128_ _065_ VGND VGND VPWR VPWR _139_ sky130_fd_sc_hd__o21ba_1
X_212_ _073_ _080_ VGND VGND VPWR VPWR _081_ sky130_fd_sc_hd__and2_1
XFILLER_19_55 VGND VGND VPWR VPWR sky130_fd_sc_hd__fill_1
XPHY_EDGE_ROW_27_Left_57 VGND VGND VPWR VPWR sky130_fd_sc_hd__decap_3
XFILLER_18_153 VPWR VGND VPWR VGND sky130_ef_sc_hd__decap_12
XFILLER_24_112 VGND VGND VPWR VPWR sky130_fd_sc_hd__decap_8
XFILLER_21_78 VGND VGND VPWR VPWR sky130_fd_sc_hd__decap_8
XTAP_TAPCELL_ROW_25_140 VGND VPWR sky130_fd_sc_hd__tapvpwrvgnd_1
XFILLER_15_167 VGND VGND VPWR VPWR sky130_fd_sc_hd__fill_1
XFILLER_21_148 VPWR VGND VPWR VGND sky130_ef_sc_hd__decap_12
XPHY_EDGE_ROW_0_Right_0 VGND VGND VPWR VPWR sky130_fd_sc_hd__decap_3
XPHY_EDGE_ROW_14_Left_44 VGND VGND VPWR VPWR sky130_fd_sc_hd__decap_3
XFILLER_27_99 VPWR VGND VPWR VGND sky130_ef_sc_hd__decap_12
X_391_ clknet_2_2__leaf_clk _045_ net26 VGND VGND VPWR VPWR u_tx.shreg\[6\] sky130_fd_sc_hd__dfstp_1
XFILLER_4_15 VPWR VGND VPWR VGND sky130_ef_sc_hd__decap_12
Xfanout25 u_rx.state\[2\] VGND VGND VPWR VPWR net25 sky130_fd_sc_hd__buf_2
XFILLER_1_125 VGND VGND VPWR VPWR sky130_fd_sc_hd__decap_8
X_374_ clknet_2_2__leaf_clk _030_ net27 VGND VGND VPWR VPWR u_rx.cnt\[7\] sky130_fd_sc_hd__dfrtp_1
XFILLER_24_78 VGND VGND VPWR VPWR sky130_fd_sc_hd__decap_6
XFILLER_1_27 VPWR VGND VPWR VGND sky130_ef_sc_hd__decap_12
XFILLER_6_3 VPWR VGND VPWR VGND sky130_ef_sc_hd__decap_12
X_357_ clknet_2_2__leaf_clk _019_ net27 VGND VGND VPWR VPWR u_tx.bitidx\[3\] sky130_fd_sc_hd__dfrtp_1
Xinput4 tx_data[1] VGND VGND VPWR VPWR net4 sky130_fd_sc_hd__clkbuf_1
X_288_ _135_ _138_ VGND VGND VPWR VPWR _025_ sky130_fd_sc_hd__and2_1
Xclkbuf_2_1__f_clk clknet_0_clk VGND VGND VPWR VPWR clknet_2_1__leaf_clk sky130_fd_sc_hd__clkbuf_16
XFILLER_27_143 VGND VGND VPWR VPWR sky130_fd_sc_hd__fill_1
X_211_ _053_ u_tx.cnt\[0\] _076_ _077_ _052_ VGND VGND VPWR VPWR _080_ sky130_fd_sc_hd__a41o_1
XFILLER_19_89 VGND VGND VPWR VPWR sky130_fd_sc_hd__decap_3
XFILLER_19_23 VGND VGND VPWR VPWR sky130_fd_sc_hd__decap_3
XFILLER_18_165 VPWR VGND VPWR VGND sky130_ef_sc_hd__decap_12
XPHY_EDGE_ROW_2_Left_32 VGND VGND VPWR VPWR sky130_fd_sc_hd__decap_3
XFILLER_15_113 VGND VGND VPWR VPWR sky130_fd_sc_hd__fill_2
XFILLER_15_102 VGND VGND VPWR VPWR sky130_fd_sc_hd__fill_2
XFILLER_7_15 VPWR VGND VPWR VGND sky130_ef_sc_hd__decap_12
XFILLER_21_127 VGND VGND VPWR VPWR sky130_fd_sc_hd__decap_8
X_390_ clknet_2_2__leaf_clk _044_ net26 VGND VGND VPWR VPWR u_tx.shreg\[5\] sky130_fd_sc_hd__dfstp_1
XFILLER_4_27 VGND VGND VPWR VPWR sky130_fd_sc_hd__fill_1
Xfanout26 net28 VGND VGND VPWR VPWR net26 sky130_fd_sc_hd__clkbuf_4
X_373_ clknet_2_0__leaf_clk _029_ net28 VGND VGND VPWR VPWR u_rx.cnt\[6\] sky130_fd_sc_hd__dfrtp_1
X_356_ clknet_2_3__leaf_clk _018_ net27 VGND VGND VPWR VPWR u_tx.bitidx\[2\] sky130_fd_sc_hd__dfrtp_1
Xinput5 tx_data[2] VGND VGND VPWR VPWR net5 sky130_fd_sc_hd__clkbuf_1
XFILLER_1_39 VPWR VGND VPWR VGND sky130_ef_sc_hd__decap_12
X_287_ u_rx.cnt\[1\] u_rx.cnt\[0\] _137_ u_rx.cnt\[2\] VGND VGND VPWR VPWR _138_ sky130_fd_sc_hd__a31o_1
XFILLER_27_177 VGND VGND VPWR VPWR sky130_fd_sc_hd__fill_2
XFILLER_27_111 VGND VGND VPWR VPWR sky130_fd_sc_hd__fill_1
XFILLER_19_57 VPWR VGND VPWR VGND sky130_ef_sc_hd__decap_12
XFILLER_19_35 VPWR VGND VPWR VGND sky130_ef_sc_hd__decap_12
XFILLER_10_15 VPWR VGND VPWR VGND sky130_ef_sc_hd__decap_12
X_210_ net39 _073_ _079_ VGND VGND VPWR VPWR _006_ sky130_fd_sc_hd__a21oi_1
XFILLER_18_177 VGND VGND VPWR VPWR sky130_fd_sc_hd__fill_2
X_339_ u_tx.shreg\[4\] net6 _087_ VGND VGND VPWR VPWR _043_ sky130_fd_sc_hd__mux2_1
XFILLER_15_169 VGND VGND VPWR VPWR sky130_fd_sc_hd__fill_2
XFILLER_7_27 VGND VGND VPWR VPWR sky130_fd_sc_hd__fill_2
XFILLER_7_49 VGND VGND VPWR VPWR sky130_fd_sc_hd__fill_2
XFILLER_16_6 VPWR VGND VPWR VGND sky130_ef_sc_hd__decap_12
XFILLER_20_150 VGND VGND VPWR VPWR sky130_fd_sc_hd__decap_4
XFILLER_7_143 VGND VGND VPWR VPWR sky130_fd_sc_hd__fill_1
XFILLER_27_68 VGND VGND VPWR VPWR sky130_fd_sc_hd__decap_8
XFILLER_27_57 VGND VGND VPWR VPWR sky130_fd_sc_hd__decap_4
XFILLER_4_168 VGND VGND VPWR VPWR sky130_fd_sc_hd__decap_3
Xfanout27 net28 VGND VGND VPWR VPWR net27 sky130_fd_sc_hd__clkbuf_2
XFILLER_13_15 VGND VGND VPWR VPWR sky130_fd_sc_hd__decap_3
XFILLER_1_105 VGND VGND VPWR VPWR sky130_fd_sc_hd__decap_6
X_372_ clknet_2_0__leaf_clk _028_ net28 VGND VGND VPWR VPWR u_rx.cnt\[5\] sky130_fd_sc_hd__dfrtp_1
X_355_ clknet_2_2__leaf_clk _017_ net27 VGND VGND VPWR VPWR u_tx.bitidx\[1\] sky130_fd_sc_hd__dfrtp_2
X_286_ u_rx.state\[0\] _129_ VGND VGND VPWR VPWR _137_ sky130_fd_sc_hd__or2_2
Xinput6 tx_data[3] VGND VGND VPWR VPWR net6 sky130_fd_sc_hd__clkbuf_1
XFILLER_19_69 VPWR VGND VPWR VGND sky130_ef_sc_hd__decap_12
XFILLER_19_47 VGND VGND VPWR VPWR sky130_fd_sc_hd__decap_8
XFILLER_10_27 VGND VGND VPWR VPWR sky130_fd_sc_hd__fill_1
XFILLER_10_49 VGND VGND VPWR VPWR sky130_fd_sc_hd__decap_3
XFILLER_27_156 VPWR VGND VPWR VGND sky130_ef_sc_hd__decap_12
XFILLER_27_123 VPWR VGND VPWR VGND sky130_ef_sc_hd__decap_12
XPHY_EDGE_ROW_23_Right_23 VGND VGND VPWR VPWR sky130_fd_sc_hd__decap_3
XPHY_EDGE_ROW_14_Right_14 VGND VGND VPWR VPWR sky130_fd_sc_hd__decap_3
XFILLER_25_90 VGND VGND VPWR VPWR sky130_fd_sc_hd__fill_1
XFILLER_24_159 VPWR VGND VPWR VGND sky130_ef_sc_hd__decap_12
X_338_ u_tx.shreg\[3\] net5 _087_ VGND VGND VPWR VPWR _042_ sky130_fd_sc_hd__mux2_1
XFILLER_2_83 VGND VGND VPWR VPWR sky130_fd_sc_hd__fill_1
X_269_ _056_ _123_ u_rx.state\[1\] VGND VGND VPWR VPWR _124_ sky130_fd_sc_hd__and3b_1
XFILLER_15_159 VGND VGND VPWR VPWR sky130_fd_sc_hd__decap_8
XTAP_TAPCELL_ROW_13_102 VGND VPWR sky130_fd_sc_hd__tapvpwrvgnd_1
XPHY_EDGE_ROW_4_Right_4 VGND VGND VPWR VPWR sky130_fd_sc_hd__decap_3
XFILLER_8_93 VGND VGND VPWR VPWR sky130_fd_sc_hd__decap_3
XFILLER_27_25 VPWR VGND VPWR VGND sky130_ef_sc_hd__decap_12
XFILLER_4_29 VPWR VGND VPWR VGND sky130_ef_sc_hd__decap_12
XFILLER_4_114 VGND VGND VPWR VPWR sky130_fd_sc_hd__decap_3
XPHY_EDGE_ROW_18_Left_48 VGND VGND VPWR VPWR sky130_fd_sc_hd__decap_3
X_371_ clknet_2_2__leaf_clk _027_ net26 VGND VGND VPWR VPWR u_rx.cnt\[4\] sky130_fd_sc_hd__dfrtp_2
Xfanout28 net1 VGND VGND VPWR VPWR net28 sky130_fd_sc_hd__buf_2
XFILLER_0_161 VGND VGND VPWR VPWR sky130_fd_sc_hd__decap_6
XFILLER_24_59 VGND VGND VPWR VPWR sky130_fd_sc_hd__decap_6
XFILLER_24_37 VGND VGND VPWR VPWR sky130_fd_sc_hd__fill_1
XFILLER_5_61 VGND VGND VPWR VPWR sky130_fd_sc_hd__fill_1
X_354_ clknet_2_2__leaf_clk _016_ net26 VGND VGND VPWR VPWR u_tx.bitidx\[0\] sky130_fd_sc_hd__dfrtp_4
X_285_ net25 u_rx.state\[0\] VGND VGND VPWR VPWR _136_ sky130_fd_sc_hd__nor2_1
Xinput7 tx_data[4] VGND VGND VPWR VPWR net7 sky130_fd_sc_hd__clkbuf_1
XFILLER_27_135 VGND VGND VPWR VPWR sky130_fd_sc_hd__decap_8
XFILLER_27_113 VGND VGND VPWR VPWR sky130_fd_sc_hd__decap_4
XFILLER_19_15 VGND VGND VPWR VPWR sky130_fd_sc_hd__decap_8
XFILLER_4_3 VPWR VGND VPWR VGND sky130_ef_sc_hd__decap_12
X_337_ u_tx.shreg\[2\] net4 _087_ VGND VGND VPWR VPWR _041_ sky130_fd_sc_hd__mux2_1
XFILLER_25_80 VGND VGND VPWR VPWR sky130_fd_sc_hd__fill_2
XFILLER_18_135 VGND VGND VPWR VPWR sky130_fd_sc_hd__decap_4
XFILLER_18_124 VGND VGND VPWR VPWR sky130_fd_sc_hd__fill_2
X_199_ _071_ _072_ VGND VGND VPWR VPWR _002_ sky130_fd_sc_hd__or2_1
X_268_ u_rx.idx\[1\] u_rx.idx\[0\] VGND VGND VPWR VPWR _123_ sky130_fd_sc_hd__or2_1
XFILLER_24_149 VGND VGND VPWR VPWR sky130_fd_sc_hd__decap_3
XFILLER_21_16 VGND VGND VPWR VPWR sky130_fd_sc_hd__decap_6
XPHY_EDGE_ROW_6_Left_36 VGND VGND VPWR VPWR sky130_fd_sc_hd__decap_3
XTAP_TAPCELL_ROW_16_111 VGND VPWR sky130_fd_sc_hd__tapvpwrvgnd_1
Xinput10 tx_data[7] VGND VGND VPWR VPWR net10 sky130_fd_sc_hd__clkbuf_1
XFILLER_20_141 VGND VGND VPWR VPWR sky130_fd_sc_hd__decap_3
XFILLER_16_27 VGND VGND VPWR VPWR sky130_fd_sc_hd__fill_1
XFILLER_20_163 VPWR VGND VPWR VGND sky130_ef_sc_hd__decap_12
XTAP_TAPCELL_ROW_13_103 VGND VPWR sky130_fd_sc_hd__tapvpwrvgnd_1
XFILLER_22_81 VGND VGND VPWR VPWR sky130_fd_sc_hd__decap_3
XFILLER_21_6 VGND VGND VPWR VPWR sky130_fd_sc_hd__fill_1
XFILLER_7_167 VGND VGND VPWR VPWR sky130_fd_sc_hd__fill_1
XFILLER_7_178 VGND VGND VPWR VPWR sky130_fd_sc_hd__fill_1
XFILLER_27_37 VGND VGND VPWR VPWR sky130_fd_sc_hd__decap_6
XFILLER_13_39 VPWR VGND VPWR VGND sky130_ef_sc_hd__decap_12
Xfanout29 net31 VGND VGND VPWR VPWR net29 sky130_fd_sc_hd__clkbuf_4
X_370_ clknet_2_0__leaf_clk _026_ net29 VGND VGND VPWR VPWR u_rx.cnt\[3\] sky130_fd_sc_hd__dfrtp_1
X_353_ clknet_2_3__leaf_clk _015_ net27 VGND VGND VPWR VPWR net21 sky130_fd_sc_hd__dfstp_1
XFILLER_14_71 VGND VGND VPWR VPWR sky130_fd_sc_hd__fill_1
X_284_ _128_ _134_ _130_ u_rx.cnt\[2\] VGND VGND VPWR VPWR _135_ sky130_fd_sc_hd__a2bb2o_1
Xinput8 tx_data[5] VGND VGND VPWR VPWR net8 sky130_fd_sc_hd__clkbuf_1
XFILLER_27_169 VGND VGND VPWR VPWR sky130_fd_sc_hd__decap_8
X_336_ u_tx.shreg\[1\] net3 _087_ VGND VGND VPWR VPWR _040_ sky130_fd_sc_hd__mux2_1
X_198_ net23 u_rx.state\[0\] VGND VGND VPWR VPWR _072_ sky130_fd_sc_hd__and2b_1
X_267_ u_rx.idx\[1\] u_rx.idx\[0\] VGND VGND VPWR VPWR _122_ sky130_fd_sc_hd__nor2_1
XPHY_EDGE_ROW_22_Left_52 VGND VGND VPWR VPWR sky130_fd_sc_hd__decap_3
XTAP_TAPCELL_ROW_19_120 VGND VPWR sky130_fd_sc_hd__tapvpwrvgnd_1
XFILLER_2_85 VPWR VGND VPWR VGND sky130_ef_sc_hd__decap_12
XFILLER_2_41 VPWR VGND VPWR VGND sky130_ef_sc_hd__decap_12
Xinput11 tx_start VGND VGND VPWR VPWR net11 sky130_fd_sc_hd__buf_1
XTAP_TAPCELL_ROW_16_112 VGND VPWR sky130_fd_sc_hd__tapvpwrvgnd_1
XTAP_TAPCELL_ROW_7_84 VGND VPWR sky130_fd_sc_hd__tapvpwrvgnd_1
X_319_ _118_ _158_ _161_ VGND VGND VPWR VPWR _162_ sky130_fd_sc_hd__nor3b_2
XFILLER_20_175 VGND VGND VPWR VPWR sky130_fd_sc_hd__decap_4
XTAP_TAPCELL_ROW_13_104 VGND VPWR sky130_fd_sc_hd__tapvpwrvgnd_1
XFILLER_7_113 VPWR VGND VPWR VGND sky130_ef_sc_hd__decap_12
XFILLER_12_3 VPWR VGND VPWR VGND sky130_ef_sc_hd__decap_12
XFILLER_0_141 VGND VGND VPWR VPWR sky130_fd_sc_hd__decap_4
XFILLER_5_96 VPWR VGND VPWR VGND sky130_ef_sc_hd__decap_12
X_352_ clknet_2_3__leaf_clk _014_ net30 VGND VGND VPWR VPWR u_tx.cnt\[8\] sky130_fd_sc_hd__dfrtp_1
Xinput9 tx_data[6] VGND VGND VPWR VPWR net9 sky130_fd_sc_hd__clkbuf_1
X_283_ u_rx.cnt\[1\] u_rx.cnt\[0\] u_rx.cnt\[2\] VGND VGND VPWR VPWR _134_ sky130_fd_sc_hd__and3_1
XFILLER_18_104 VPWR VGND VPWR VGND sky130_ef_sc_hd__decap_12
X_266_ u_rx.idx\[0\] _121_ _120_ VGND VGND VPWR VPWR _020_ sky130_fd_sc_hd__mux2_1
X_197_ _066_ _067_ _068_ net25 VGND VGND VPWR VPWR _071_ sky130_fd_sc_hd__o31a_1
X_335_ net24 _056_ _167_ _171_ VGND VGND VPWR VPWR _039_ sky130_fd_sc_hd__a31o_1
XTAP_TAPCELL_ROW_19_121 VGND VPWR sky130_fd_sc_hd__tapvpwrvgnd_1
XFILLER_2_97 VPWR VGND VPWR VGND sky130_ef_sc_hd__decap_12
XFILLER_2_53 VPWR VGND VPWR VGND sky130_ef_sc_hd__decap_12
XPHY_EDGE_ROW_10_Right_10 VGND VGND VPWR VPWR sky130_fd_sc_hd__decap_3
XFILLER_23_140 VGND VGND VPWR VPWR sky130_fd_sc_hd__decap_6
XFILLER_11_51 VGND VGND VPWR VPWR sky130_fd_sc_hd__fill_2
X_249_ _108_ VGND VGND VPWR VPWR _109_ sky130_fd_sc_hd__inv_2
XTAP_TAPCELL_ROW_16_113 VGND VPWR sky130_fd_sc_hd__tapvpwrvgnd_1
XTAP_TAPCELL_ROW_7_85 VGND VPWR sky130_fd_sc_hd__tapvpwrvgnd_1
X_318_ u_rx.idx\[2\] _122_ VGND VGND VPWR VPWR _161_ sky130_fd_sc_hd__xnor2_1
XFILLER_20_154 VGND VGND VPWR VPWR sky130_fd_sc_hd__fill_1
XFILLER_20_132 VGND VGND VPWR VPWR sky130_fd_sc_hd__decap_8
XFILLER_16_29 VPWR VGND VPWR VGND sky130_ef_sc_hd__decap_12
XFILLER_7_147 VPWR VGND VPWR VGND sky130_ef_sc_hd__decap_12
XFILLER_7_125 VPWR VGND VPWR VGND sky130_ef_sc_hd__decap_12
XFILLER_8_41 VPWR VGND VPWR VGND sky130_ef_sc_hd__decap_12
XFILLER_8_85 VGND VGND VPWR VPWR sky130_fd_sc_hd__decap_8
XFILLER_4_106 VGND VGND VPWR VPWR sky130_fd_sc_hd__decap_8
Xhold1 u_rx.rx_s1 VGND VGND VPWR VPWR net32 sky130_fd_sc_hd__dlygate4sd3_1
XTAP_TAPCELL_ROW_4_75 VGND VPWR sky130_fd_sc_hd__tapvpwrvgnd_1
XPHY_EDGE_ROW_8_Right_8 VGND VGND VPWR VPWR sky130_fd_sc_hd__decap_3
XFILLER_28_93 VGND VGND VPWR VPWR sky130_fd_sc_hd__fill_1
XFILLER_24_29 VGND VGND VPWR VPWR sky130_fd_sc_hd__decap_8
X_351_ clknet_2_3__leaf_clk _013_ net30 VGND VGND VPWR VPWR u_tx.cnt\[7\] sky130_fd_sc_hd__dfrtp_1
X_282_ _066_ _132_ _133_ _130_ u_rx.cnt\[1\] VGND VGND VPWR VPWR _024_ sky130_fd_sc_hd__a32o_1
XFILLER_18_116 VGND VGND VPWR VPWR sky130_fd_sc_hd__decap_8
X_334_ _057_ _159_ net41 VGND VGND VPWR VPWR _171_ sky130_fd_sc_hd__o21a_1
XTAP_TAPCELL_ROW_19_122 VGND VPWR sky130_fd_sc_hd__tapvpwrvgnd_1
X_196_ net25 net23 _069_ _070_ VGND VGND VPWR VPWR _000_ sky130_fd_sc_hd__a31o_1
XFILLER_2_65 VPWR VGND VPWR VGND sky130_ef_sc_hd__decap_12
X_265_ u_rx.state\[2\] u_rx.idx\[0\] VGND VGND VPWR VPWR _121_ sky130_fd_sc_hd__nor2_1
XFILLER_23_163 VGND VGND VPWR VPWR sky130_fd_sc_hd__decap_4
XTAP_TAPCELL_ROW_11_96 VGND VPWR sky130_fd_sc_hd__tapvpwrvgnd_1
X_248_ _075_ _078_ _080_ _073_ VGND VGND VPWR VPWR _108_ sky130_fd_sc_hd__o211a_1
X_317_ net24 net37 _160_ VGND VGND VPWR VPWR _032_ sky130_fd_sc_hd__mux2_1
XFILLER_14_141 VPWR VGND VPWR VGND sky130_ef_sc_hd__decap_12
XFILLER_2_3 VPWR VGND VPWR VGND sky130_ef_sc_hd__decap_12
X_179_ net14 VGND VGND VPWR VPWR _055_ sky130_fd_sc_hd__inv_2
XTAP_TAPCELL_ROW_7_86 VGND VPWR sky130_fd_sc_hd__tapvpwrvgnd_1
Xclkbuf_2_2__f_clk clknet_0_clk VGND VGND VPWR VPWR clknet_2_2__leaf_clk sky130_fd_sc_hd__clkbuf_16
XFILLER_7_104 VGND VGND VPWR VPWR sky130_fd_sc_hd__decap_8
XFILLER_7_137 VGND VGND VPWR VPWR sky130_fd_sc_hd__decap_6
XFILLER_7_159 VGND VGND VPWR VPWR sky130_fd_sc_hd__decap_8
XFILLER_11_111 VGND VGND VPWR VPWR sky130_fd_sc_hd__fill_1
XFILLER_8_53 VGND VGND VPWR VPWR sky130_fd_sc_hd__decap_6
XFILLER_17_95 VPWR VGND VPWR VGND sky130_ef_sc_hd__decap_12
Xhold2 net16 VGND VGND VPWR VPWR net33 sky130_fd_sc_hd__dlygate4sd3_1
XTAP_TAPCELL_ROW_4_76 VGND VPWR sky130_fd_sc_hd__tapvpwrvgnd_1
XFILLER_5_87 VGND VGND VPWR VPWR sky130_fd_sc_hd__fill_2
X_350_ clknet_2_3__leaf_clk _012_ net30 VGND VGND VPWR VPWR u_tx.cnt\[6\] sky130_fd_sc_hd__dfrtp_1
XFILLER_14_85 VGND VGND VPWR VPWR sky130_fd_sc_hd__decap_4
XFILLER_14_63 VGND VGND VPWR VPWR sky130_fd_sc_hd__fill_2
XTAP_TAPCELL_ROW_1_66 VGND VPWR sky130_fd_sc_hd__tapvpwrvgnd_1
X_281_ _061_ _127_ net25 VGND VGND VPWR VPWR _133_ sky130_fd_sc_hd__a21o_1
XFILLER_27_117 VGND VGND VPWR VPWR sky130_fd_sc_hd__fill_1
XFILLER_18_139 VGND VGND VPWR VPWR sky130_fd_sc_hd__fill_1
X_195_ net23 u_rx.state\[0\] u_rx.state\[3\] _062_ VGND VGND VPWR VPWR _070_ sky130_fd_sc_hd__a22o_1
XFILLER_2_77 VGND VGND VPWR VPWR sky130_fd_sc_hd__decap_6
X_333_ net24 net36 _170_ VGND VGND VPWR VPWR _038_ sky130_fd_sc_hd__mux2_1
X_264_ _001_ _117_ _119_ VGND VGND VPWR VPWR _120_ sky130_fd_sc_hd__and3_1
XTAP_TAPCELL_ROW_11_97 VGND VPWR sky130_fd_sc_hd__tapvpwrvgnd_1
X_247_ net21 _080_ _082_ _107_ VGND VGND VPWR VPWR _015_ sky130_fd_sc_hd__o22a_1
XPHY_EDGE_ROW_26_Left_56 VGND VGND VPWR VPWR sky130_fd_sc_hd__decap_3
XFILLER_14_153 VGND VGND VPWR VPWR sky130_fd_sc_hd__decap_6
X_316_ u_rx.idx\[2\] _123_ _159_ VGND VGND VPWR VPWR _160_ sky130_fd_sc_hd__or3_1
XFILLER_11_64 VGND VGND VPWR VPWR sky130_fd_sc_hd__fill_2
XFILLER_11_97 VGND VGND VPWR VPWR sky130_fd_sc_hd__decap_6
XFILLER_28_3 VPWR VGND VPWR VGND sky130_ef_sc_hd__decap_12
XTAP_TAPCELL_ROW_22_129 VGND VPWR sky130_fd_sc_hd__tapvpwrvgnd_1
X_178_ u_tx.cnt\[6\] VGND VGND VPWR VPWR _054_ sky130_fd_sc_hd__inv_2
XFILLER_20_123 VGND VGND VPWR VPWR sky130_fd_sc_hd__decap_6
XFILLER_22_85 VGND VGND VPWR VPWR sky130_fd_sc_hd__decap_6
XFILLER_22_41 VPWR VGND VPWR VGND sky130_ef_sc_hd__decap_12
XFILLER_11_167 VGND VGND VPWR VPWR sky130_fd_sc_hd__fill_1
XTAP_TAPCELL_ROW_4_77 VGND VPWR sky130_fd_sc_hd__tapvpwrvgnd_1
Xhold3 net13 VGND VGND VPWR VPWR net34 sky130_fd_sc_hd__dlygate4sd3_1
XPHY_EDGE_ROW_13_Left_43 VGND VGND VPWR VPWR sky130_fd_sc_hd__decap_3
XFILLER_0_155 VGND VGND VPWR VPWR sky130_fd_sc_hd__fill_2
XFILLER_10_3 VPWR VGND VPWR VGND sky130_ef_sc_hd__decap_12
XFILLER_14_53 VGND VGND VPWR VPWR sky130_fd_sc_hd__fill_2
X_280_ u_rx.cnt\[1\] u_rx.cnt\[0\] VGND VGND VPWR VPWR _132_ sky130_fd_sc_hd__nand2_1
XTAP_TAPCELL_ROW_1_67 VGND VPWR sky130_fd_sc_hd__tapvpwrvgnd_1
X_332_ u_rx.idx\[0\] _168_ u_rx.idx\[1\] VGND VGND VPWR VPWR _170_ sky130_fd_sc_hd__or3b_1
X_194_ net25 _065_ _069_ _064_ VGND VGND VPWR VPWR _001_ sky130_fd_sc_hd__a31o_1
X_263_ _071_ _118_ VGND VGND VPWR VPWR _119_ sky130_fd_sc_hd__nor2_1
XTAP_TAPCELL_ROW_11_98 VGND VPWR sky130_fd_sc_hd__tapvpwrvgnd_1
XTAP_TAPCELL_ROW_25_138 VGND VPWR sky130_fd_sc_hd__tapvpwrvgnd_1
XFILLER_23_121 VGND VGND VPWR VPWR sky130_fd_sc_hd__decap_3
XPHY_EDGE_ROW_1_Left_31 VGND VGND VPWR VPWR sky130_fd_sc_hd__decap_3
X_177_ u_tx.cnt\[1\] VGND VGND VPWR VPWR _053_ sky130_fd_sc_hd__inv_2
X_246_ _104_ _106_ _052_ VGND VGND VPWR VPWR _107_ sky130_fd_sc_hd__a21oi_1
X_315_ _118_ _158_ VGND VGND VPWR VPWR _159_ sky130_fd_sc_hd__or2_1
XFILLER_22_53 VGND VGND VPWR VPWR sky130_fd_sc_hd__fill_2
XFILLER_11_113 VGND VGND VPWR VPWR sky130_fd_sc_hd__decap_3
XFILLER_11_157 VGND VGND VPWR VPWR sky130_fd_sc_hd__fill_1
X_229_ net43 _091_ _093_ VGND VGND VPWR VPWR _011_ sky130_fd_sc_hd__a21o_1
XFILLER_3_153 VGND VGND VPWR VPWR sky130_fd_sc_hd__decap_6
Xhold4 net15 VGND VGND VPWR VPWR net35 sky130_fd_sc_hd__dlygate4sd3_1
XFILLER_28_85 VGND VGND VPWR VPWR sky130_fd_sc_hd__decap_8
XPHY_EDGE_ROW_26_Right_26 VGND VGND VPWR VPWR sky130_fd_sc_hd__decap_3
XPHY_EDGE_ROW_17_Right_17 VGND VGND VPWR VPWR sky130_fd_sc_hd__decap_3
XFILLER_0_167 VGND VGND VPWR VPWR sky130_fd_sc_hd__fill_1
XFILLER_0_145 VGND VGND VPWR VPWR sky130_fd_sc_hd__fill_1
XFILLER_14_76 VGND VGND VPWR VPWR sky130_fd_sc_hd__decap_8
XTAP_TAPCELL_ROW_1_68 VGND VPWR sky130_fd_sc_hd__tapvpwrvgnd_1
XTAP_TAPCELL_ROW_28_147 VGND VPWR sky130_fd_sc_hd__tapvpwrvgnd_1
XFILLER_26_141 VGND VGND VPWR VPWR sky130_fd_sc_hd__fill_1
XFILLER_25_86 VGND VGND VPWR VPWR sky130_fd_sc_hd__decap_4
X_331_ net24 _050_ u_rx.idx\[0\] _167_ _169_ VGND VGND VPWR VPWR _037_ sky130_fd_sc_hd__a41o_1
X_262_ _058_ _059_ _060_ u_rx.state\[1\] VGND VGND VPWR VPWR _118_ sky130_fd_sc_hd__o31a_1
X_193_ _066_ _067_ _068_ VGND VGND VPWR VPWR _069_ sky130_fd_sc_hd__nor3_2
XFILLER_17_141 VPWR VGND VPWR VGND sky130_ef_sc_hd__decap_12
XTAP_TAPCELL_ROW_25_139 VGND VPWR sky130_fd_sc_hd__tapvpwrvgnd_1
XFILLER_23_177 VGND VGND VPWR VPWR sky130_fd_sc_hd__fill_2
X_176_ net22 VGND VGND VPWR VPWR _052_ sky130_fd_sc_hd__inv_2
X_245_ u_tx.bitidx\[3\] _105_ _074_ VGND VGND VPWR VPWR _106_ sky130_fd_sc_hd__o21ai_1
X_314_ u_rx.state\[2\] u_rx.state\[0\] u_rx.state\[3\] VGND VGND VPWR VPWR _158_ sky130_fd_sc_hd__or3_1
XFILLER_11_103 VGND VGND VPWR VPWR sky130_fd_sc_hd__fill_1
XFILLER_0_3 VPWR VGND VPWR VGND sky130_ef_sc_hd__decap_12
XFILLER_8_67 VGND VGND VPWR VPWR sky130_fd_sc_hd__decap_8
XFILLER_11_169 VGND VGND VPWR VPWR sky130_fd_sc_hd__fill_2
X_228_ u_tx.cnt\[5\] _085_ _089_ VGND VGND VPWR VPWR _093_ sky130_fd_sc_hd__and3b_1
XFILLER_17_54 VGND VGND VPWR VPWR sky130_fd_sc_hd__fill_2
XFILLER_3_110 VGND VGND VPWR VPWR sky130_fd_sc_hd__fill_2
Xhold5 net18 VGND VGND VPWR VPWR net36 sky130_fd_sc_hd__dlygate4sd3_1
XFILLER_3_165 VGND VGND VPWR VPWR sky130_fd_sc_hd__decap_3
XFILLER_0_113 VPWR VGND VPWR VGND sky130_ef_sc_hd__decap_12
XFILLER_28_53 VGND VGND VPWR VPWR sky130_fd_sc_hd__decap_4
XFILLER_5_35 VGND VGND VPWR VPWR sky130_fd_sc_hd__fill_1
XFILLER_5_57 VGND VGND VPWR VPWR sky130_fd_sc_hd__decap_4
XFILLER_5_79 VGND VGND VPWR VPWR sky130_fd_sc_hd__decap_8
XTAP_TAPCELL_ROW_28_148 VGND VPWR sky130_fd_sc_hd__tapvpwrvgnd_1
XFILLER_25_54 VGND VGND VPWR VPWR sky130_fd_sc_hd__fill_2
X_330_ u_rx.idx\[1\] _051_ _168_ net40 VGND VGND VPWR VPWR _169_ sky130_fd_sc_hd__o31a_1
X_261_ _057_ _061_ _065_ VGND VGND VPWR VPWR _117_ sky130_fd_sc_hd__o21a_1
X_192_ u_rx.cnt\[8\] u_rx.cnt\[2\] u_rx.cnt\[5\] u_rx.cnt\[3\] VGND VGND VPWR VPWR
+ _068_ sky130_fd_sc_hd__or4b_1
XFILLER_17_153 VPWR VGND VPWR VGND sky130_ef_sc_hd__decap_12
XFILLER_23_167 VGND VGND VPWR VPWR sky130_fd_sc_hd__fill_1
XFILLER_23_101 VGND VGND VPWR VPWR sky130_fd_sc_hd__decap_8
X_244_ u_tx.shreg\[1\] u_tx.shreg\[2\] u_tx.bitidx\[0\] VGND VGND VPWR VPWR _105_
+ sky130_fd_sc_hd__mux2_1
X_313_ net25 _062_ _130_ u_rx.cnt\[8\] _157_ VGND VGND VPWR VPWR _031_ sky130_fd_sc_hd__a221o_1
XFILLER_14_112 VPWR VGND VPWR VGND sky130_ef_sc_hd__decap_12
X_175_ u_rx.idx\[0\] VGND VGND VPWR VPWR _051_ sky130_fd_sc_hd__inv_2
XFILLER_11_137 VPWR VGND VPWR VGND sky130_ef_sc_hd__decap_12
X_227_ _091_ _092_ VGND VGND VPWR VPWR _010_ sky130_fd_sc_hd__and2_1
XFILLER_6_141 VGND VGND VPWR VPWR sky130_fd_sc_hd__decap_8
Xhold6 net12 VGND VGND VPWR VPWR net37 sky130_fd_sc_hd__dlygate4sd3_1
XPHY_EDGE_ROW_3_Right_3 VGND VGND VPWR VPWR sky130_fd_sc_hd__decap_3
XFILLER_0_169 VGND VGND VPWR VPWR sky130_fd_sc_hd__decap_4
XFILLER_0_125 VPWR VGND VPWR VGND sky130_ef_sc_hd__decap_12
XPHY_EDGE_ROW_17_Left_47 VGND VGND VPWR VPWR sky130_fd_sc_hd__decap_3
XFILLER_14_45 VGND VGND VPWR VPWR sky130_fd_sc_hd__fill_2
XTAP_TAPCELL_ROW_28_149 VGND VPWR sky130_fd_sc_hd__tapvpwrvgnd_1
XFILLER_26_176 VGND VGND VPWR VPWR sky130_fd_sc_hd__decap_3
X_260_ u_tx.bitidx\[3\] _114_ _116_ _110_ VGND VGND VPWR VPWR _019_ sky130_fd_sc_hd__a22o_1
X_389_ clknet_2_2__leaf_clk _043_ net26 VGND VGND VPWR VPWR u_tx.shreg\[4\] sky130_fd_sc_hd__dfstp_1
XFILLER_17_165 VGND VGND VPWR VPWR sky130_fd_sc_hd__decap_3
XFILLER_2_15 VPWR VGND VPWR VGND sky130_ef_sc_hd__decap_12
X_191_ u_rx.cnt\[4\] u_rx.cnt\[7\] u_rx.cnt\[6\] VGND VGND VPWR VPWR _067_ sky130_fd_sc_hd__nand3_1
XFILLER_23_113 VGND VGND VPWR VPWR sky130_fd_sc_hd__decap_8
X_243_ _101_ _103_ u_tx.bitidx\[3\] VGND VGND VPWR VPWR _104_ sky130_fd_sc_hd__a21o_1
X_312_ _049_ _155_ _156_ _061_ _129_ VGND VGND VPWR VPWR _157_ sky130_fd_sc_hd__o2111a_1
XFILLER_14_124 VPWR VGND VPWR VGND sky130_ef_sc_hd__decap_12
X_174_ u_rx.idx\[1\] VGND VGND VPWR VPWR _050_ sky130_fd_sc_hd__inv_2
XPHY_EDGE_ROW_5_Left_35 VGND VGND VPWR VPWR sky130_fd_sc_hd__decap_3
XFILLER_11_149 VGND VGND VPWR VPWR sky130_fd_sc_hd__decap_8
X_226_ u_tx.cnt\[3\] u_tx.cnt\[2\] _083_ u_tx.cnt\[4\] VGND VGND VPWR VPWR _092_ sky130_fd_sc_hd__a31o_1
XFILLER_6_120 VGND VGND VPWR VPWR sky130_fd_sc_hd__decap_3
XTAP_TAPCELL_ROW_12_100 VGND VPWR sky130_fd_sc_hd__tapvpwrvgnd_1
Xhold7 u_tx.cnt\[8\] VGND VGND VPWR VPWR net38 sky130_fd_sc_hd__dlygate4sd3_1
XFILLER_3_145 VGND VGND VPWR VPWR sky130_fd_sc_hd__fill_1
X_209_ net22 net39 VGND VGND VPWR VPWR _079_ sky130_fd_sc_hd__nor2_1
XFILLER_0_81 VGND VGND VPWR VPWR sky130_fd_sc_hd__decap_3
XFILLER_0_137 VGND VGND VPWR VPWR sky130_fd_sc_hd__decap_3
XFILLER_5_15 VPWR VGND VPWR VGND sky130_ef_sc_hd__decap_12
XPHY_EDGE_ROW_22_Right_22 VGND VGND VPWR VPWR sky130_fd_sc_hd__decap_3
XPHY_EDGE_ROW_13_Right_13 VGND VGND VPWR VPWR sky130_fd_sc_hd__decap_3
XTAP_TAPCELL_ROW_5_80 VGND VPWR sky130_fd_sc_hd__tapvpwrvgnd_1
XFILLER_14_24 VGND VGND VPWR VPWR sky130_fd_sc_hd__decap_4
XFILLER_29_141 VPWR VGND VPWR VGND sky130_ef_sc_hd__decap_12
XFILLER_25_67 VGND VGND VPWR VPWR sky130_fd_sc_hd__decap_4
XFILLER_25_34 VPWR VGND VPWR VGND sky130_ef_sc_hd__decap_12
XFILLER_25_23 VGND VGND VPWR VPWR sky130_fd_sc_hd__fill_2
XFILLER_17_177 VGND VGND VPWR VPWR sky130_fd_sc_hd__fill_2
XFILLER_17_111 VGND VGND VPWR VPWR sky130_fd_sc_hd__fill_1
XFILLER_2_27 VGND VGND VPWR VPWR sky130_fd_sc_hd__fill_1
X_190_ u_rx.cnt\[1\] u_rx.cnt\[0\] VGND VGND VPWR VPWR _066_ sky130_fd_sc_hd__or2_1
XFILLER_23_169 VGND VGND VPWR VPWR sky130_fd_sc_hd__decap_8
X_388_ clknet_2_2__leaf_clk _042_ net26 VGND VGND VPWR VPWR u_tx.shreg\[3\] sky130_fd_sc_hd__dfstp_1
XTAP_TAPCELL_ROW_2_70 VGND VPWR sky130_fd_sc_hd__tapvpwrvgnd_1
X_242_ u_tx.bitidx\[2\] _102_ u_tx.bitidx\[1\] VGND VGND VPWR VPWR _103_ sky130_fd_sc_hd__nand3b_1
X_173_ u_rx.cnt\[8\] VGND VGND VPWR VPWR _049_ sky130_fd_sc_hd__inv_2
X_311_ u_rx.cnt\[7\] _152_ u_rx.cnt\[8\] VGND VGND VPWR VPWR _156_ sky130_fd_sc_hd__a21o_1
XFILLER_14_136 VGND VGND VPWR VPWR sky130_fd_sc_hd__decap_4
XPHY_EDGE_ROW_21_Left_51 VGND VGND VPWR VPWR sky130_fd_sc_hd__decap_3
XFILLER_22_68 VGND VGND VPWR VPWR sky130_fd_sc_hd__fill_1
XFILLER_22_24 VGND VGND VPWR VPWR sky130_fd_sc_hd__decap_4
X_225_ _081_ _090_ VGND VGND VPWR VPWR _091_ sky130_fd_sc_hd__nor2_1
XFILLER_8_15 VPWR VGND VPWR VGND sky130_ef_sc_hd__decap_12
XFILLER_8_59 VGND VGND VPWR VPWR sky130_fd_sc_hd__fill_1
XTAP_TAPCELL_ROW_12_101 VGND VPWR sky130_fd_sc_hd__tapvpwrvgnd_1
Xhold8 u_tx.cnt\[0\] VGND VGND VPWR VPWR net39 sky130_fd_sc_hd__dlygate4sd3_1
XFILLER_17_57 VPWR VGND VPWR VGND sky130_ef_sc_hd__decap_12
XFILLER_17_46 VGND VGND VPWR VPWR sky130_fd_sc_hd__decap_8
XFILLER_17_35 VGND VGND VPWR VPWR sky130_fd_sc_hd__fill_2
XFILLER_3_113 VPWR VGND VPWR VGND sky130_ef_sc_hd__decap_12
X_208_ net23 u_rx.state\[3\] _062_ VGND VGND VPWR VPWR _004_ sky130_fd_sc_hd__and3_1
XFILLER_28_78 VGND VGND VPWR VPWR sky130_fd_sc_hd__decap_6
Xclkbuf_2_3__f_clk clknet_0_clk VGND VGND VPWR VPWR clknet_2_3__leaf_clk sky130_fd_sc_hd__clkbuf_16
XFILLER_5_27 VGND VGND VPWR VPWR sky130_fd_sc_hd__decap_8
XFILLER_29_153 VPWR VGND VPWR VGND sky130_ef_sc_hd__decap_12
XFILLER_25_57 VGND VGND VPWR VPWR sky130_fd_sc_hd__decap_3
XFILLER_25_46 VGND VGND VPWR VPWR sky130_fd_sc_hd__decap_8
XFILLER_9_3 VPWR VGND VPWR VGND sky130_ef_sc_hd__decap_12
X_387_ clknet_2_2__leaf_clk _041_ net26 VGND VGND VPWR VPWR u_tx.shreg\[2\] sky130_fd_sc_hd__dfstp_1
XTAP_TAPCELL_ROW_2_71 VGND VPWR sky130_fd_sc_hd__tapvpwrvgnd_1
X_310_ _146_ _154_ _155_ _145_ u_rx.cnt\[7\] VGND VGND VPWR VPWR _030_ sky130_fd_sc_hd__a32o_1
XFILLER_11_15 VPWR VGND VPWR VGND sky130_ef_sc_hd__decap_12
X_241_ u_tx.shreg\[3\] u_tx.shreg\[4\] u_tx.bitidx\[0\] VGND VGND VPWR VPWR _102_
+ sky130_fd_sc_hd__mux2_1
XTAP_TAPCELL_ROW_15_110 VGND VPWR sky130_fd_sc_hd__tapvpwrvgnd_1
X_172_ net25 VGND VGND VPWR VPWR _048_ sky130_fd_sc_hd__inv_2
XFILLER_11_107 VGND VGND VPWR VPWR sky130_fd_sc_hd__decap_4
X_224_ u_tx.cnt\[3\] u_tx.cnt\[2\] u_tx.cnt\[4\] _083_ VGND VGND VPWR VPWR _090_ sky130_fd_sc_hd__and4_1
XFILLER_6_133 VGND VGND VPWR VPWR sky130_fd_sc_hd__fill_1
XFILLER_8_27 VGND VGND VPWR VPWR sky130_fd_sc_hd__fill_1
XFILLER_26_6 VGND VGND VPWR VPWR sky130_fd_sc_hd__fill_2
XFILLER_17_69 VGND VGND VPWR VPWR sky130_fd_sc_hd__decap_6
XFILLER_3_125 VPWR VGND VPWR VGND sky130_ef_sc_hd__decap_12
XFILLER_3_169 VGND VGND VPWR VPWR sky130_fd_sc_hd__fill_1
Xhold9 net17 VGND VGND VPWR VPWR net40 sky130_fd_sc_hd__dlygate4sd3_1
X_207_ _075_ _078_ _073_ VGND VGND VPWR VPWR _005_ sky130_fd_sc_hd__o21a_1
XFILLER_28_57 VGND VGND VPWR VPWR sky130_fd_sc_hd__fill_1
XFILLER_14_37 VGND VGND VPWR VPWR sky130_fd_sc_hd__decap_8
XPHY_EDGE_ROW_7_Right_7 VGND VGND VPWR VPWR sky130_fd_sc_hd__decap_3
XFILLER_29_165 VGND VGND VPWR VPWR sky130_fd_sc_hd__decap_3
XFILLER_29_121 VGND VGND VPWR VPWR sky130_fd_sc_hd__fill_1
XFILLER_6_82 VGND VGND VPWR VPWR sky130_fd_sc_hd__fill_2
XFILLER_26_168 VGND VGND VPWR VPWR sky130_fd_sc_hd__decap_8
X_386_ clknet_2_2__leaf_clk _040_ net26 VGND VGND VPWR VPWR u_tx.shreg\[1\] sky130_fd_sc_hd__dfstp_1
XFILLER_2_29 VPWR VGND VPWR VGND sky130_ef_sc_hd__decap_12
XFILLER_11_27 VPWR VGND VPWR VGND sky130_ef_sc_hd__decap_12
X_240_ u_tx.bitidx\[2\] _100_ VGND VGND VPWR VPWR _101_ sky130_fd_sc_hd__nand2_1
X_369_ clknet_2_0__leaf_clk _025_ net28 VGND VGND VPWR VPWR u_rx.cnt\[2\] sky130_fd_sc_hd__dfrtp_1
XFILLER_3_61 VGND VGND VPWR VPWR sky130_fd_sc_hd__fill_1
XFILLER_9_131 VGND VGND VPWR VPWR sky130_fd_sc_hd__decap_8
X_223_ u_tx.cnt\[3\] u_tx.cnt\[2\] u_tx.cnt\[4\] VGND VGND VPWR VPWR _089_ sky130_fd_sc_hd__and3_1
XFILLER_10_141 VGND VGND VPWR VPWR sky130_fd_sc_hd__fill_2
XFILLER_12_70 VGND VGND VPWR VPWR sky130_fd_sc_hd__fill_1
XFILLER_12_92 VGND VGND VPWR VPWR sky130_fd_sc_hd__fill_1
XFILLER_3_137 VGND VGND VPWR VPWR sky130_fd_sc_hd__decap_8
XFILLER_3_159 VGND VGND VPWR VPWR sky130_fd_sc_hd__fill_1
XPHY_EDGE_ROW_9_Left_39 VGND VGND VPWR VPWR sky130_fd_sc_hd__decap_3
X_206_ _053_ u_tx.cnt\[0\] _076_ _077_ VGND VGND VPWR VPWR _078_ sky130_fd_sc_hd__nand4_1
XFILLER_9_93 VGND VGND VPWR VPWR sky130_fd_sc_hd__fill_1
XFILLER_29_177 VGND VGND VPWR VPWR sky130_fd_sc_hd__fill_2
XFILLER_29_111 VGND VGND VPWR VPWR sky130_fd_sc_hd__fill_1
XFILLER_25_15 VGND VGND VPWR VPWR sky130_fd_sc_hd__decap_8
XFILLER_6_94 VGND VGND VPWR VPWR sky130_fd_sc_hd__decap_4
XFILLER_17_169 VGND VGND VPWR VPWR sky130_fd_sc_hd__decap_8
X_385_ clknet_2_1__leaf_clk _004_ net31 VGND VGND VPWR VPWR net20 sky130_fd_sc_hd__dfrtp_1
XFILLER_23_128 VPWR VGND VPWR VGND sky130_ef_sc_hd__decap_12
XFILLER_11_39 VPWR VGND VPWR VGND sky130_ef_sc_hd__decap_12
X_299_ _144_ _146_ _147_ _145_ net44 VGND VGND VPWR VPWR _027_ sky130_fd_sc_hd__a32o_1
XFILLER_3_51 VGND VGND VPWR VPWR sky130_fd_sc_hd__decap_4
X_368_ clknet_2_0__leaf_clk _024_ net28 VGND VGND VPWR VPWR u_rx.cnt\[1\] sky130_fd_sc_hd__dfrtp_1
XPHY_EDGE_ROW_29_Right_29 VGND VGND VPWR VPWR sky130_fd_sc_hd__decap_3
XTAP_TAPCELL_ROW_21_126 VGND VPWR sky130_fd_sc_hd__tapvpwrvgnd_1
X_222_ _086_ _088_ u_tx.cnt\[3\] VGND VGND VPWR VPWR _009_ sky130_fd_sc_hd__mux2_1
XPHY_EDGE_ROW_25_Left_55 VGND VGND VPWR VPWR sky130_fd_sc_hd__decap_3
XFILLER_8_29 VPWR VGND VPWR VGND sky130_ef_sc_hd__decap_12
XFILLER_12_82 VGND VGND VPWR VPWR sky130_fd_sc_hd__fill_2
X_205_ u_tx.cnt\[3\] u_tx.cnt\[2\] u_tx.cnt\[5\] u_tx.cnt\[4\] VGND VGND VPWR VPWR
+ _077_ sky130_fd_sc_hd__and4bb_1
XFILLER_0_85 VPWR VGND VPWR VGND sky130_ef_sc_hd__decap_12
XFILLER_0_41 VPWR VGND VPWR VGND sky130_ef_sc_hd__decap_12
XFILLER_9_72 VGND VGND VPWR VPWR sky130_fd_sc_hd__fill_1
XFILLER_28_15 VPWR VGND VPWR VGND sky130_ef_sc_hd__decap_12
XFILLER_18_92 VPWR VGND VPWR VGND sky130_ef_sc_hd__decap_12
XFILLER_18_81 VGND VGND VPWR VPWR sky130_fd_sc_hd__decap_3
XPHY_EDGE_ROW_12_Left_42 VGND VGND VPWR VPWR sky130_fd_sc_hd__decap_3
XFILLER_20_82 VGND VGND VPWR VPWR sky130_fd_sc_hd__fill_2
XFILLER_26_104 VGND VGND VPWR VPWR sky130_fd_sc_hd__decap_8
X_384_ clknet_2_1__leaf_clk _039_ net31 VGND VGND VPWR VPWR net19 sky130_fd_sc_hd__dfrtp_1
XTAP_TAPCELL_ROW_24_135 VGND VPWR sky130_fd_sc_hd__tapvpwrvgnd_1
XFILLER_7_3 VPWR VGND VPWR VGND sky130_ef_sc_hd__decap_12
X_367_ clknet_2_0__leaf_clk _023_ net28 VGND VGND VPWR VPWR u_rx.cnt\[0\] sky130_fd_sc_hd__dfrtp_1
X_298_ u_rx.cnt\[4\] _140_ VGND VGND VPWR VPWR _147_ sky130_fd_sc_hd__nand2_1
XTAP_TAPCELL_ROW_21_127 VGND VPWR sky130_fd_sc_hd__tapvpwrvgnd_1
X_221_ u_tx.cnt\[2\] _085_ _088_ VGND VGND VPWR VPWR _008_ sky130_fd_sc_hd__o21a_1
XPHY_EDGE_ROW_0_Left_30 VGND VGND VPWR VPWR sky130_fd_sc_hd__decap_3
X_204_ u_tx.cnt\[6\] u_tx.cnt\[7\] u_tx.cnt\[8\] VGND VGND VPWR VPWR _076_ sky130_fd_sc_hd__and3b_1
XFILLER_24_6 VGND VGND VPWR VPWR sky130_fd_sc_hd__fill_1
XFILLER_0_97 VPWR VGND VPWR VGND sky130_ef_sc_hd__decap_12
XFILLER_0_53 VGND VGND VPWR VPWR sky130_fd_sc_hd__decap_3
XFILLER_9_51 VGND VGND VPWR VPWR sky130_fd_sc_hd__decap_4
XFILLER_28_27 VGND VGND VPWR VPWR sky130_fd_sc_hd__fill_1
XFILLER_0_109 VGND VGND VPWR VPWR sky130_fd_sc_hd__decap_3
XFILLER_29_113 VGND VGND VPWR VPWR sky130_fd_sc_hd__decap_4
XFILLER_20_50 VGND VGND VPWR VPWR sky130_fd_sc_hd__decap_4
XFILLER_26_127 VPWR VGND VPWR VGND sky130_ef_sc_hd__decap_12
XFILLER_6_41 VGND VGND VPWR VPWR sky130_fd_sc_hd__fill_2
XFILLER_6_52 VGND VGND VPWR VPWR sky130_fd_sc_hd__fill_1
XTAP_TAPCELL_ROW_27_144 VGND VPWR sky130_fd_sc_hd__tapvpwrvgnd_1
X_383_ clknet_2_1__leaf_clk _038_ net31 VGND VGND VPWR VPWR net18 sky130_fd_sc_hd__dfrtp_1
XTAP_TAPCELL_ROW_24_136 VGND VPWR sky130_fd_sc_hd__tapvpwrvgnd_1
XFILLER_22_141 VGND VGND VPWR VPWR sky130_fd_sc_hd__decap_6
X_297_ _061_ _127_ _071_ VGND VGND VPWR VPWR _146_ sky130_fd_sc_hd__a21o_1
X_366_ clknet_2_2__leaf_clk net2 net28 VGND VGND VPWR VPWR u_rx.rx_s1 sky130_fd_sc_hd__dfstp_1
XFILLER_22_29 VPWR VGND VPWR VGND sky130_ef_sc_hd__decap_12
XTAP_TAPCELL_ROW_21_128 VGND VPWR sky130_fd_sc_hd__tapvpwrvgnd_1
XFILLER_3_86 VPWR VGND VPWR VGND sky130_ef_sc_hd__decap_12
X_220_ _086_ _087_ VGND VGND VPWR VPWR _088_ sky130_fd_sc_hd__nor2_1
XFILLER_12_51 VGND VGND VPWR VPWR sky130_fd_sc_hd__decap_6
X_349_ clknet_2_3__leaf_clk _011_ net31 VGND VGND VPWR VPWR u_tx.cnt\[5\] sky130_fd_sc_hd__dfrtp_1
X_203_ net22 u_tx.bitidx\[0\] u_tx.bitidx\[3\] _074_ VGND VGND VPWR VPWR _075_ sky130_fd_sc_hd__nand4_1
XFILLER_23_61 VPWR VGND VPWR VGND sky130_ef_sc_hd__decap_12
XFILLER_17_6 VGND VGND VPWR VPWR sky130_fd_sc_hd__decap_8
XFILLER_29_169 VGND VGND VPWR VPWR sky130_fd_sc_hd__decap_8
XFILLER_6_64 VGND VGND VPWR VPWR sky130_fd_sc_hd__decap_3
XFILLER_26_139 VGND VGND VPWR VPWR sky130_fd_sc_hd__fill_1
XFILLER_17_117 VPWR VGND VPWR VGND sky130_ef_sc_hd__decap_12
XTAP_TAPCELL_ROW_27_145 VGND VPWR sky130_fd_sc_hd__tapvpwrvgnd_1
XFILLER_25_150 VPWR VGND VPWR VGND sky130_ef_sc_hd__decap_12
XFILLER_23_109 VGND VGND VPWR VPWR sky130_fd_sc_hd__decap_3
X_382_ clknet_2_1__leaf_clk _037_ net31 VGND VGND VPWR VPWR net17 sky130_fd_sc_hd__dfrtp_1
XTAP_TAPCELL_ROW_24_137 VGND VPWR sky130_fd_sc_hd__tapvpwrvgnd_1
XFILLER_26_94 VGND VGND VPWR VPWR sky130_fd_sc_hd__fill_1
XFILLER_26_83 VGND VGND VPWR VPWR sky130_fd_sc_hd__fill_1
X_296_ net25 net23 _069_ _130_ VGND VGND VPWR VPWR _145_ sky130_fd_sc_hd__a31o_1
X_365_ clknet_2_0__leaf_clk _003_ net29 VGND VGND VPWR VPWR u_rx.state\[3\] sky130_fd_sc_hd__dfrtp_1
XFILLER_3_98 VPWR VGND VPWR VGND sky130_ef_sc_hd__decap_12
XFILLER_6_149 VGND VGND VPWR VPWR sky130_fd_sc_hd__fill_2
XFILLER_12_63 VGND VGND VPWR VPWR sky130_fd_sc_hd__fill_2
XFILLER_12_74 VGND VGND VPWR VPWR sky130_fd_sc_hd__decap_8
XFILLER_12_85 VGND VGND VPWR VPWR sky130_fd_sc_hd__decap_4
XFILLER_12_96 VGND VGND VPWR VPWR sky130_fd_sc_hd__decap_8
XPHY_EDGE_ROW_25_Right_25 VGND VGND VPWR VPWR sky130_fd_sc_hd__decap_3
X_348_ clknet_2_3__leaf_clk _010_ net31 VGND VGND VPWR VPWR u_tx.cnt\[4\] sky130_fd_sc_hd__dfrtp_1
XPHY_EDGE_ROW_16_Right_16 VGND VGND VPWR VPWR sky130_fd_sc_hd__decap_3
X_279_ _131_ _130_ u_rx.cnt\[0\] VGND VGND VPWR VPWR _023_ sky130_fd_sc_hd__mux2_1
XPHY_EDGE_ROW_29_Left_59 VGND VGND VPWR VPWR sky130_fd_sc_hd__decap_3
X_202_ u_tx.bitidx\[1\] u_tx.bitidx\[2\] VGND VGND VPWR VPWR _074_ sky130_fd_sc_hd__nor2_1
XFILLER_23_73 VPWR VGND VPWR VGND sky130_ef_sc_hd__decap_12
XFILLER_2_141 VPWR VGND VPWR VGND sky130_ef_sc_hd__decap_12
XFILLER_28_29 VGND VGND VPWR VPWR sky130_fd_sc_hd__decap_3
XFILLER_18_73 VGND VGND VPWR VPWR sky130_fd_sc_hd__decap_8
XPHY_EDGE_ROW_2_Right_2 VGND VGND VPWR VPWR sky130_fd_sc_hd__decap_3
XFILLER_20_74 VGND VGND VPWR VPWR sky130_fd_sc_hd__decap_8
XFILLER_6_98 VGND VGND VPWR VPWR sky130_fd_sc_hd__fill_1
XPHY_EDGE_ROW_16_Left_46 VGND VGND VPWR VPWR sky130_fd_sc_hd__decap_3
XTAP_TAPCELL_ROW_27_146 VGND VPWR sky130_fd_sc_hd__tapvpwrvgnd_1
XFILLER_25_162 VGND VGND VPWR VPWR sky130_fd_sc_hd__decap_6
XFILLER_17_129 VPWR VGND VPWR VGND sky130_ef_sc_hd__decap_12
XFILLER_17_107 VGND VGND VPWR VPWR sky130_fd_sc_hd__decap_4
XFILLER_15_30 VGND VGND VPWR VPWR sky130_fd_sc_hd__decap_4
X_381_ clknet_2_1__leaf_clk _036_ net29 VGND VGND VPWR VPWR net16 sky130_fd_sc_hd__dfrtp_1
XFILLER_26_62 VGND VGND VPWR VPWR sky130_fd_sc_hd__fill_2
XFILLER_22_132 VGND VGND VPWR VPWR sky130_fd_sc_hd__decap_8
X_364_ clknet_2_0__leaf_clk _002_ net30 VGND VGND VPWR VPWR u_rx.state\[2\] sky130_fd_sc_hd__dfrtp_1
XFILLER_13_165 VGND VGND VPWR VPWR sky130_fd_sc_hd__decap_3
X_295_ u_rx.cnt\[4\] _141_ VGND VGND VPWR VPWR _144_ sky130_fd_sc_hd__or2_1
XFILLER_3_55 VGND VGND VPWR VPWR sky130_fd_sc_hd__fill_1
XFILLER_9_169 VGND VGND VPWR VPWR sky130_fd_sc_hd__fill_2
X_347_ clknet_2_3__leaf_clk _009_ net30 VGND VGND VPWR VPWR u_tx.cnt\[3\] sky130_fd_sc_hd__dfrtp_1
XFILLER_5_3 VPWR VGND VPWR VGND sky130_ef_sc_hd__decap_12
XFILLER_6_139 VGND VGND VPWR VPWR sky130_fd_sc_hd__fill_1
XTAP_TAPCELL_ROW_8_87 VGND VPWR sky130_fd_sc_hd__tapvpwrvgnd_1
X_278_ _071_ _127_ VGND VGND VPWR VPWR _131_ sky130_fd_sc_hd__or2_1
X_201_ net22 net11 VGND VGND VPWR VPWR _073_ sky130_fd_sc_hd__or2_2
XFILLER_23_85 VGND VGND VPWR VPWR sky130_fd_sc_hd__decap_8
XFILLER_23_41 VGND VGND VPWR VPWR sky130_fd_sc_hd__fill_2
XFILLER_2_153 VGND VGND VPWR VPWR sky130_fd_sc_hd__decap_6
XPHY_EDGE_ROW_4_Left_34 VGND VGND VPWR VPWR sky130_fd_sc_hd__decap_3
XFILLER_18_85 VGND VGND VPWR VPWR sky130_fd_sc_hd__decap_3
XFILLER_18_52 VGND VGND VPWR VPWR sky130_fd_sc_hd__fill_1
XFILLER_29_105 VGND VGND VPWR VPWR sky130_fd_sc_hd__decap_6
XFILLER_26_119 VGND VGND VPWR VPWR sky130_fd_sc_hd__fill_1
X_380_ clknet_2_1__leaf_clk _035_ net29 VGND VGND VPWR VPWR net15 sky130_fd_sc_hd__dfrtp_1
.ends
